* SPDX-License-Identifier: Apache-2.0
* QFN40 6x6 first-order package model, generated from
* results/ihp130/package/qfn40_pkg_rlc.json.
* Series R-L from the PAD side to the package lead, shunt C at the lead.
* This is not a 3D EM or IBIS signoff model; L/R/C are bounded estimates.
* Default values are the median of the 40 extracted pins.

.subckt qfn40_pkg in out params: L=2.19n R=0.108 C=0.1p
Lpkg in n1 {L}
Rpkg n1 out {R}
Cpkg out 0 {C}
.ends qfn40_pkg

* Per-pin extracted values:
* pin pad wire_um L_nH R_ohm
*  1 W9    2288.3  2.478 0.1197
*  2 W8    2181.1  2.347 0.1144
*  3 W7    2004.7  2.133 0.1056
*  4 W6    1855.8  1.955 0.0983
*  5 W5    1770.9  1.854 0.0940
*  6 W4    1770.9  1.854 0.0940
*  7 W3    1855.8  1.955 0.0983
*  8 W2    2004.7  2.133 0.1056
*  9 W1    2181.1  2.347 0.1144
* 10 W0    2380.8  2.592 0.1243
* 11 S0    2380.8  2.592 0.1243
* 12 S1    2181.1  2.347 0.1144
* 13 S2    2004.7  2.133 0.1056
* 14 S3    1855.8  1.955 0.0983
* 15 S4    1770.9  1.854 0.0940
* 16 S5    1770.9  1.854 0.0940
* 17 S6    1855.8  1.955 0.0983
* 18 S7    2004.7  2.133 0.1056
* 19 S8    2181.1  2.347 0.1144
* 20 S9    2380.8  2.592 0.1243
* 21 E0    2380.8  2.592 0.1243
* 22 E1    2181.1  2.347 0.1144
* 23 E2    2004.7  2.133 0.1056
* 24 E3    1855.8  1.955 0.0983
* 25 E4    1770.9  1.854 0.0940
* 26 E5    1770.9  1.854 0.0940
* 27 E6    1855.8  1.955 0.0983
* 28 E7    2250.7  2.432 0.1179
* 29 E8    2459.3  2.690 0.1283
* 30 E9    2380.8  2.592 0.1243
* 31 N9    2380.8  2.592 0.1243
* 32 N8    2181.1  2.347 0.1144
* 33 N7    2004.7  2.133 0.1056
* 34 N6    1855.8  1.955 0.0983
* 35 N5    1770.9  1.854 0.0940
* 36 N4    1770.9  1.854 0.0940
* 37 N3    1855.8  1.955 0.0983
* 38 N2    2004.7  2.133 0.1056
* 39 N1    2181.1  2.347 0.1144
* 40 N0    2288.3  2.478 0.1197
