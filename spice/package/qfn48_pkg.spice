* SPDX-License-Identifier: Apache-2.0
* QFN48 7x7 first-order package model, generated from
* results/ihp130/package/qfn48_pkg_rlc.json.
* Series R-L from the PAD side to the package lead, shunt C at the lead.
* This is not a 3D EM or IBIS signoff model; L/R/C are bounded estimates.
* Default values are the median of the 48 extracted pins.

.subckt qfn48_pkg in out params: L=2.56n R=0.123 C=0.1p
Lpkg in n1 {L}
Rpkg n1 out {R}
Cpkg out 0 {C}
.ends qfn48_pkg

* Per-pin extracted values:
* pin pad wire_um L_nH R_ohm
*  1 W11   2735.1  3.036 0.1419
*  2 W10   2535.4  2.785 0.1320
*  3 W9    2355.9  2.562 0.1231
*  4 W8    2211.4  2.384 0.1159
*  5 W7    2109.3  2.260 0.1109
*  6 W6    2055.7  2.195 0.1082
*  7 W5    2055.7  2.195 0.1082
*  8 W4    2109.3  2.260 0.1109
*  9 W3    2211.5  2.384 0.1159
* 10 W2    2356.0  2.562 0.1231
* 11 W1    2535.5  2.785 0.1320
* 12 W0    2721.3  3.019 0.1413
* 13 S0    2721.2  3.019 0.1413
* 14 S1    2535.4  2.785 0.1320
* 15 S2    2355.9  2.562 0.1231
* 16 S3    2211.4  2.384 0.1159
* 17 S4    2109.3  2.260 0.1109
* 18 S5    2055.7  2.195 0.1082
* 19 S6    2055.7  2.195 0.1082
* 20 S7    2109.3  2.260 0.1109
* 21 S8    2211.5  2.384 0.1159
* 22 S9    2356.0  2.562 0.1231
* 23 S10   2535.5  2.785 0.1320
* 24 S11   2720.1  3.017 0.1412
* 25 E0    2721.1  3.019 0.1413
* 26 E1    2535.5  2.785 0.1320
* 27 E2    2356.0  2.562 0.1231
* 28 E3    2211.5  2.384 0.1159
* 29 E4    2109.3  2.260 0.1109
* 30 E5    2055.7  2.195 0.1082
* 31 E6    2055.7  2.195 0.1082
* 32 E7    2109.3  2.260 0.1109
* 33 E8    2211.4  2.384 0.1159
* 34 E9    2355.9  2.562 0.1231
* 35 E10   2535.4  2.785 0.1320
* 36 E11   2721.3  3.019 0.1413
* 37 N11   2721.2  3.019 0.1413
* 38 N10   2535.5  2.785 0.1320
* 39 N9    2356.0  2.562 0.1231
* 40 N8    2211.5  2.384 0.1159
* 41 N7    2109.3  2.260 0.1109
* 42 N6    2055.7  2.195 0.1082
* 43 N5    2055.7  2.195 0.1082
* 44 N4    2109.3  2.260 0.1109
* 45 N3    2211.4  2.384 0.1159
* 46 N2    2355.9  2.562 0.1231
* 47 N1    2535.4  2.785 0.1320
* 48 N0    2735.2  3.037 0.1420
