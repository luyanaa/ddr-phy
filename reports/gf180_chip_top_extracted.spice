* Extracted by KLayout with GF180MCU LVS runset on : 28/11/2026 07:07

* cell gf180mcu_sdram_chip_top
.SUBCKT gf180mcu_sdram_chip_top
* cell instance $1 r0 *1 263.5,25
X$1 \$I843 VSSIO \$I1337 \$I1308 \$I1279 \$I1250 \$I1221 \$I1192 \$I1163
+ \$I1134 \$I1105 \$I1076 \$I1047 \$I1018 \$I989 \$I960 \$I931 \$I902 \$I873
+ \$I815 \$I786 \$I757 \$I728 \$I699 \$I670 \$I641 \$I612 pad_cmd[11] VSSIO
+ VSSIO VDDIO VDDIO VDDIO VDDIO \$I380 \$I350 \$I275 \$I304 \$I239 \$I210 \$225
+ gf180_pad_tile
* cell instance $2 r180 *1 206.5,1775
X$2 VSSIO VSSIO \$I1349 \$I1320 \$I1291 \$I1262 \$I1233 \$I1204 \$I1175 \$I1146
+ VSSIO VDDIO VDDIO VDDIO \$I1000 \$I971 \$I942 \$I913 \$I884 \$I826 \$I797
+ \$I768 \$I739 \$I710 \$I681 \$I652 \$I623 pad_cmd[7] VSSIO VSSIO \$I507 VDDIO
+ \$I449 VDDIO \$I392 \$I362 \$I287 \$I316 \$I250 \$I221 \$98401 gf180_pad_tile
* cell instance $3 r180 *1 1536.5,1775
X$3 \$I861 VSSIO \$I1354 \$I1325 \$I1296 \$I1267 \$I1238 \$I1209 \$I1180
+ \$I1151 \$I1122 VDDIO VDDIO VDDIO \$I1006 \$I977 \$I948 \$I919 \$I890 \$I832
+ \$I803 \$I774 \$I745 \$I716 \$I687 \$I658 \$I629 pad_cmd[20] VSSIO VSSIO
+ \$I513 VDDIO \$I455 VDDIO \$I397 \$I367 \$I292 \$I321 \$I256 \$I227 \$109954
+ gf180_pad_tile
* cell instance $4 r180 *1 1726.5,1775
X$4 VSSIO VSSIO VSSIO VSSIO VSSIO \$108266 \$I1237 \$I1208 \$I1179 \$I1150
+ \$I1121 VDDIO VDDIO VDDIO \$I1005 \$I976 \$I947 \$I918 \$I889 \$I831 \$I802
+ \$I773 \$I744 \$I715 \$I686 \$I657 \$I628 pad_dq[7] VSSIO VSSIO \$I512 VDDIO
+ \$I454 VDDIO \$I396 \$I366 \$I291 \$I320 \$108266 \$1196 \$110803
+ gf180_pad_tile
* cell instance $5 r180 *1 1346.5,1775
X$5 \$I859 VSSIO \$I1353 \$I1324 \$I1295 \$I1266 \$I1236 \$I1207 \$I1178
+ \$I1149 \$I1120 VDDIO VDDIO VDDIO \$I1004 \$I975 \$I946 \$I917 \$I888 \$I830
+ \$I801 \$I772 \$I743 \$I714 \$I685 \$I656 \$I627 pad_cmd[19] VSSIO VSSIO
+ \$I511 VDDIO \$I453 VDDIO \$I395 \$I365 \$I290 \$I319 \$I254 \$I225 \$103851
+ gf180_pad_tile
* cell instance $6 r180 *1 1156.5,1775
X$6 \$98401 VSSIO \$I1352 \$I1323 \$I1294 \$I1265 \$I1235 \$I1206 \$I1177
+ \$I1148 \$I1119 VDDIO VDDIO VDDIO \$I1003 \$I974 \$I945 \$I916 \$I887 \$I829
+ \$I800 \$I771 \$I742 \$I713 \$I684 \$I655 \$I626 pad_cmd[18] VSSIO VSSIO
+ \$I510 VDDIO \$I452 VDDIO \$98401 \$213824 \$98401 \$98401 \$I253 \$I224
+ \$100212 gf180_pad_tile
* cell instance $7 r180 *1 586.5,1775
X$7 \$I857 VSSIO \$I1351 \$I1322 \$I1293 \$I1264 \$I1234 \$I1205 \$I1176
+ \$I1147 \$I1118 VDDIO VDDIO VDDIO \$I1002 \$I973 \$I944 \$I915 \$I886 \$I828
+ \$I799 \$I770 \$I741 \$I712 \$I683 \$I654 \$I625 pad_cmd[9] VSSIO VSSIO
+ \$I509 VDDIO \$I451 VDDIO \$I394 \$213824 \$98401 \$I318 \$I252 \$I223
+ \$98401 gf180_pad_tile
* cell instance $8 r180 *1 776.5,1775
X$8 \$I856 VSSIO \$I1350 \$I1321 \$I1292 \$I1263 \$108266 \$108266 \$108266
+ \$108266 \$I1117 VDDIO VDDIO VDDIO \$I1001 \$I972 \$I943 \$I914 \$I885 \$I827
+ \$I798 \$I769 \$I740 \$I711 \$I682 \$I653 \$I624 pad_cmd[10] VSSIO VSSIO
+ \$I508 VDDIO \$I450 VDDIO \$I393 \$213824 \$98401 \$I317 \$I251 \$I222
+ \$102034 gf180_pad_tile
* cell instance $9 r180 *1 966.5,1775
X$9 \$I854 VSSIO \$I1348 \$I1319 \$I1290 \$I1261 \$I1232 \$I1203 \$I1174
+ \$I1145 \$I1116 VDDIO VDDIO VDDIO \$I999 \$I970 \$I941 \$I912 \$I883 \$I825
+ \$I796 \$I767 \$I738 \$I709 \$I680 \$I651 \$I622 pad_cmd[17] VSSIO VSSIO
+ \$I506 VDDIO \$I448 VDDIO \$I391 \$213824 \$98401 \$I315 \$I249 \$I220
+ \$98401 gf180_pad_tile
* cell instance $10 r180 *1 396.5,1775
X$10 \$I853 VSSIO \$I1347 \$I1318 \$I1289 \$I1260 \$I1231 \$I1202 \$I1173
+ \$I1144 \$I1115 VDDIO VDDIO VDDIO \$I998 \$I969 \$I940 \$I911 \$I882 \$I824
+ \$I795 \$I766 \$I737 \$I708 \$I679 \$I650 \$I621 pad_cmd[8] VSSIO VSSIO
+ \$I505 VDDIO \$I447 VDDIO \$I390 \$213824 \$98401 \$I314 \$I248 \$I219
+ \$105640 gf180_pad_tile
* cell instance $11 r270 *1 25,728.16
X$11 \$I868 VSSIO \$I1361 \$I1332 \$I1303 \$I1274 \$I1245 \$I1216 \$I1187
+ \$I1158 \$I1129 \$I1100 \$I1071 \$I1042 \$I1013 \$I984 \$I955 \$I926 \$I897
+ \$I839 \$I810 \$I781 \$I752 \$I723 \$I694 \$I665 \$I636 pad_cmd[2] VSSIO
+ VSSIO VDDIO VDDIO VDDIO VDDIO \$I404 \$I374 \$I299 \$I328 \$I263 \$I234
+ \$82142 gf180_pad_tile
* cell instance $12 r270 *1 25,348.16
X$12 \$I867 VSSIO \$I1360 \$I1331 \$I1302 \$I1273 \$I1244 \$I1215 \$I1186
+ \$I1157 \$I1128 \$I1099 \$I1070 \$I1041 \$I1012 \$I983 \$I954 \$I925 \$I896
+ \$I838 \$I809 \$I780 \$I751 \$I722 \$I693 \$I664 \$I635 pad_cmd[0] VSSIO
+ VSSIO VDDIO VDDIO VDDIO VDDIO \$I403 \$I373 \$I298 \$I327 \$I262 \$I233
+ \$20679 gf180_pad_tile
* cell instance $13 r270 *1 25,1108.16
X$13 \$I866 VSSIO \$I1359 \$I1330 \$I1301 \$I1272 \$I1243 \$I1214 \$I1185
+ \$I1156 \$I1127 \$I1098 \$I1069 \$I1040 \$I1011 \$I982 \$I953 \$I924 \$I895
+ \$I837 \$I808 \$I779 \$I750 \$I721 \$I692 \$I663 \$I634 pad_cmd[4] VSSIO
+ VSSIO VDDIO VDDIO VDDIO VDDIO \$I402 \$I372 \$I297 \$I326 \$I261 \$I232
+ VDD|VSS gf180_pad_tile
* cell instance $14 r270 *1 25,918.16
X$14 \$I865 VSSIO \$I1358 \$I1329 \$I1300 \$I1271 \$I1242 \$I1213 \$I1184
+ \$I1155 \$I1126 \$I1097 \$I1068 \$I1039 \$I1010 \$I981 \$I952 \$I923 \$I894
+ \$I836 \$I807 \$I778 \$I749 \$I720 \$I691 \$I662 \$I633 pad_cmd[3] VSSIO
+ VSSIO VDDIO VDDIO VDDIO VDDIO \$I401 \$I371 \$I296 \$I325 \$I260 \$I231
+ \$108109 gf180_pad_tile
* cell instance $15 r270 *1 25,1488.16
X$15 \$I864 VSSIO \$I1357 \$I1328 \$I1299 \$I1270 \$I1241 \$I1212 \$I1183
+ \$I1154 \$I1125 \$I1096 \$I1067 \$I1038 \$I1009 \$I980 \$I951 \$I922 \$I893
+ \$I835 \$I806 \$I777 \$I748 \$I719 \$I690 \$I661 \$I632 pad_cmd[6] VSSIO
+ VSSIO VDDIO VDDIO VDDIO VDDIO \$I400 \$I370 \$I295 \$I324 \$I259 \$I230
+ \$107310 gf180_pad_tile
* cell instance $16 r270 *1 25,1298.16
X$16 \$I863 VSSIO \$I1356 \$I1327 \$I1298 \$I1269 \$I1240 \$I1211 \$I1182
+ \$I1153 \$I1124 \$I1095 \$I1066 \$I1037 \$I1008 \$I979 \$I950 \$I921 \$I892
+ \$I834 \$I805 \$I776 \$I747 \$I718 \$I689 \$I660 \$I631 pad_cmd[5] VSSIO
+ VSSIO VDDIO VDDIO VDDIO VDDIO \$I399 \$I369 \$I294 \$I323 \$I258 \$I229
+ \$117895 gf180_pad_tile
* cell instance $17 r270 *1 25,538.16
X$17 \$I862 VSSIO \$I1355 \$I1326 \$I1297 \$I1268 \$I1239 \$I1210 \$I1181
+ \$I1152 \$I1123 \$I1094 \$I1065 \$I1036 \$I1007 \$I978 \$I949 \$I920 \$I891
+ \$I833 \$I804 \$I775 \$I746 \$I717 \$I688 \$I659 \$I630 pad_cmd[1] VSSIO
+ VSSIO VDDIO VDDIO VDDIO VDDIO \$I398 \$I368 \$I293 \$I322 \$I257 \$I228
+ \$51757 gf180_pad_tile
* cell instance $18 r0 *1 833.5,25
X$18 \$I845 VSSIO \$I1339 \$I1310 \$I1281 \$I1252 \$I1223 \$I1194 \$I1165
+ \$I1136 \$I1107 \$I1078 \$I1049 \$I1020 \$I991 \$I962 \$I933 \$I904 \$I875
+ \$18 \$18 \$18 \$18 \$22 \$22 \$22 \$22 pad_ck VSSIO VSSIO VDDIO VDDIO VDDIO
+ VDDIO \$I382 \$22 \$18 \$I306 \$I241 \$I212 \$18 gf180_pad_tile
* cell instance $19 r0 *1 453.5,25
X$19 \$I844 VSSIO \$I1338 \$I1309 \$I1280 \$I1251 \$I1222 \$I1193 \$I1164
+ \$I1135 \$I1106 \$I1077 \$I1048 \$I1019 \$I990 \$I961 \$I932 \$I903 \$I874
+ \$I816 \$I787 \$I758 \$I729 \$I700 \$I671 \$I642 \$I613 pad_cmd[12] VSSIO
+ VSSIO VDDIO VDDIO VDDIO VDDIO \$I381 \$I351 \$I276 \$I305 \$I240 \$I211 \$224
+ gf180_pad_tile
* cell instance $20 r0 *1 643.5,25
X$20 \$I842 VSSIO \$I1336 \$I1307 \$I1278 \$I1249 \$I1220 \$I1191 \$I1162
+ \$I1133 \$I1104 \$I1075 \$I1046 \$I1017 \$I988 \$I959 \$I930 \$I901 \$I872
+ \$I814 \$I785 \$I756 \$I727 \$I698 \$I669 \$I640 \$I611 pad_cmd[13] VSSIO
+ VSSIO VDDIO VDDIO VDDIO VDDIO \$I379 \$I349 \$I274 \$I303 \$I238 \$I209 \$17
+ gf180_pad_tile
* cell instance $21 r0 *1 1213.5,25
X$21 \$I841 VSSIO \$I1335 \$I1306 \$I1277 \$I1248 \$I1219 \$I1190 \$I1161
+ \$I1132 \$I1103 \$I1074 \$I1045 \$I1016 \$I987 \$I958 \$I929 \$I900 \$I871
+ \$23 \$23 \$23 \$23 \$29 \$29 \$29 \$29 pad_cmd[15] VSSIO VSSIO VDDIO VDDIO
+ VDDIO VDDIO \$I378 \$29 \$23 \$I302 \$I237 \$I208 \$24 gf180_pad_tile
* cell instance $22 r0 *1 1403.5,25
X$22 \$I840 VSSIO \$I1334 \$I1305 \$I1276 \$I1247 \$I1218 \$I1189 \$I1160
+ \$I1131 \$I1102 \$I1073 \$I1044 \$I1015 \$I986 \$I957 \$I928 \$I899 \$I870
+ \$I812 \$I783 \$I754 \$I725 \$I696 \$I667 \$I638 \$I609 pad_cmd[16] VSSIO
+ VSSIO VDDIO VDDIO VDDIO VDDIO \$I377 \$I347 \$I272 \$I301 \$I236 \$I207 \$23
+ gf180_pad_tile
* cell instance $23 r0 *1 1023.5,25
X$23 \$18 VSSIO \$I1333 \$I1304 \$I1275 \$I1246 \$I1217 \$I1188 \$I1159 \$I1130
+ \$I1101 \$I1072 \$I1043 \$I1014 \$I985 \$I956 \$I927 \$I898 \$I869 \$18 \$18
+ \$I753 \$I724 \$22 \$22 \$I637 \$I608 pad_cmd[14] VSSIO VSSIO VDDIO VDDIO
+ VDDIO VDDIO \$I376 \$I346 \$I271 \$I300 \$I235 \$I206 \$19 gf180_pad_tile
* cell instance $24 r90 *1 1775,975.16
X$24 \$I852 VSSIO \$I1346 \$I1317 \$I1288 \$I1259 \$I1230 \$I1201 \$I1172
+ \$I1143 \$I1114 \$I1085 \$I1056 \$I1027 \$I997 \$87951 \$I939 \$1196 \$1196
+ \$I823 \$I794 \$I765 \$I736 \$I707 \$I678 \$I649 \$I620 pad_dq[4] VSSIO VSSIO
+ \$I504 \$I475 \$I446 VDDIO \$I389 \$I359 \$I284 \$I313 \$87951 \$1196
+ \$116435 gf180_pad_tile
* cell instance $25 r90 *1 1775,785.16
X$25 \$I851 VSSIO \$I1345 \$I1316 \$I1287 \$I1258 \$I1229 \$I1200 \$I1171
+ \$I1142 \$I1113 \$I1084 \$I1055 \$I1026 \$I996 \$I968 \$89455 \$1196 \$1196
+ \$I822 \$I793 \$I764 \$I735 \$I706 \$I677 \$I648 \$I619 pad_dq[3] VSSIO VSSIO
+ \$I503 \$I474 \$I445 VDDIO \$I388 \$I358 \$I283 \$I312 \$89455 \$1196 \$90444
+ gf180_pad_tile
* cell instance $26 r90 *1 1775,595.16
X$26 \$I850 VSSIO \$I1344 \$I1315 \$I1286 \$I1257 \$I1228 \$I1199 \$I1170
+ \$I1141 \$I1112 \$I1083 \$I1054 \$I1025 \$I995 \$I967 \$I938 \$1196 \$1196
+ \$I821 \$I792 \$I763 \$I734 \$I705 \$I676 \$I647 \$I618 pad_dq[2] VSSIO VSSIO
+ \$I502 \$I473 \$I444 VDDIO \$I387 \$I357 \$I282 \$I311 \$72176 \$1196 \$62020
+ gf180_pad_tile
* cell instance $27 r90 *1 1775,215.16
X$27 \$I849 VSSIO \$I1343 \$I1314 \$I1285 \$I1256 \$I1227 \$I1198 \$I1169
+ \$I1140 \$I1111 \$I1082 \$I1053 \$I1024 \$I994 \$I966 \$I937 \$1196 \$1196
+ \$I820 \$I791 \$I762 \$I733 \$I704 \$I675 \$I646 \$I617 pad_dq[0] VSSIO VSSIO
+ \$I501 \$I472 \$I443 VDDIO \$I386 \$I356 \$I281 \$I310 \$9477 \$1196 \$425
+ gf180_pad_tile
* cell instance $28 r90 *1 1775,405.16
X$28 \$I848 VSSIO \$I1342 \$I1313 \$I1284 \$I1255 \$I1226 \$I1197 \$I1168
+ \$I1139 \$I1110 \$I1081 \$I1052 \$I1023 \$I993 \$I965 \$I936 \$1196 \$1196
+ \$I819 \$I790 \$I761 \$I732 \$I703 \$I674 \$I645 \$I616 pad_dq[1] VSSIO VSSIO
+ \$I500 \$I471 \$I442 VDDIO \$I385 \$I355 \$I280 \$I309 \$40626 \$1196 \$31458
+ gf180_pad_tile
* cell instance $29 r90 *1 1775,1165.16
X$29 \$I847 VSSIO \$I1341 \$I1312 \$I1283 \$I1254 \$I1225 \$I1196 \$I1167
+ \$I1138 \$I1109 \$I1080 \$I1051 \$I1022 \$I992 \$I964 \$I935 \$1196 \$1196
+ \$I818 \$I789 \$I760 \$I731 \$I702 \$I673 \$I644 \$I615 pad_dq[5] VSSIO VSSIO
+ \$I499 \$I470 \$I441 VDDIO \$I384 \$I354 \$I279 \$I308 \$109953 \$1196
+ \$124318 gf180_pad_tile
* cell instance $30 r90 *1 1775,1355.16
X$30 \$I846 VSSIO \$I1340 \$I1311 \$I1282 \$I1253 \$I1224 \$I1195 \$I1166
+ \$I1137 \$I1108 \$I1079 \$I1050 \$I1021 \$1196 \$116280 \$I934 \$I905 \$I876
+ \$I817 \$I788 \$I759 \$I730 \$I701 \$I672 \$I643 \$I614 pad_dq[6] VSSIO VSSIO
+ \$I498 \$I469 \$I440 VDDIO \$I383 \$I353 \$I278 \$I307 \$116280 \$1196
+ \$124315 gf180_pad_tile
* cell instance $31 r0 *1 762.985,754.025
X$31 \$87951 \$224 \$225 \$89455 VDD|VSS VDD|VSS \$23 \$98401 \$24 \$98401 \$19
+ \$98401 \$100212 \$102034 \$72176 \$17 \$105640 \$103851 \$108266 \$107310
+ \$51757 \$109953 \$109954 \$110803 \$82142 \$40626 \$116280 \$108109 VDD|VSS
+ \$117897 \$117895 \$20679 \$116435 \$90444 \$425 \$18 \$9477 \$124315
+ \$124318 \$62020 \$31458 sdram_phy_core
* cell instance $72 r0 *1 1042.02,985.995
X$72 VDD|VSS \$1196 \$117897 VDD|VSS VSSIO gf180mcu_as_sc_mcu7t3v3__inv_2
.ENDS gf180mcu_sdram_chip_top

* cell gf180mcu_as_sc_mcu7t3v3__inv_2
* pin VDD
* pin Y
* pin A
* pin VSS
* pin SUB
.SUBCKT gf180mcu_as_sc_mcu7t3v3__inv_2 VDD Y A VSS SUB
* device instance $1 r0 *1 0.72,2.89 pfet_03v3
M$1 Y A VDD \$5 pfet_03v3 L=0.28U W=2.76U AS=0.966P AD=0.966P PS=5.54U PD=5.54U
* device instance $3 r0 *1 0.72,0.84 nfet_03v3
M$3 Y A VSS SUB nfet_03v3 L=0.28U W=2U AS=0.7P AD=0.7P PS=4.4U PD=4.4U
.ENDS gf180mcu_as_sc_mcu7t3v3__inv_2

* cell gf180_pad_tile
* pin
* pin VSSIO
* pin
* pin
* pin
* pin
* pin
* pin
* pin
* pin
* pin
* pin
* pin
* pin
* pin
* pin
* pin
* pin
* pin
* pin
* pin
* pin
* pin
* pin
* pin
* pin
* pin
* pin
* pin
* pin
* pin
* pin
* pin
* pin
* pin
* pin
* pin
* pin
* pin
* pin
* pin
.SUBCKT gf180_pad_tile \$2 VSSIO \$I39 \$I38 \$I37 \$I36 \$I35 \$I34 \$I33
+ \$I32 \$I31 \$I30 \$I29 \$I28 \$I27 \$I26 \$I25 \$I24 \$I23 \$I22 \$I21 \$I20
+ \$I19 \$I18 \$I17 \$I16 \$I15 \$I14 \$I13 \$I12 \$I11 \$I10 \$I9 \$I8 \$I7
+ \$I6 \$I5 \$I4 \$I3 \$I2 \$I1
* cell instance $1 r0 *1 66.5,65
X$1 \$I25 \$I3 \$I8 \$I36 \$I26 \$I9 \$I11 \$I10 \$I28 \$I30 \$I29 \$I14 \$I34
+ \$I35 \$I27 \$I32 \$I33 \$I12 \$I13 \$I4 \$I5 \$I7 \$I6 \$I1 \$I18 \$I22
+ \$I17 \$I21 \$I15 \$I23 \$I19 \$I20 \$I24 \$I16 \$I2 \$I31 \$I37 \$I38 \$I39
+ VSSIO gf180_pad_core
.ENDS gf180_pad_tile

* cell sdram_phy_core
* pin dq_i[4]
* pin cmd_o[12]
* pin cmd_o[11]
* pin dq_i[3]
* pin VDD
* pin VSS
* pin cmd_o[16]
* pin cmd_o[7]
* pin cmd_o[15]
* pin cmd_o[9]
* pin cmd_o[14]
* pin cmd_o[17]
* pin cmd_o[18]
* pin cmd_o[10]
* pin dq_i[2]
* pin cmd_o[13]
* pin cmd_o[8]
* pin cmd_o[19]
* pin dq_i[7]
* pin cmd_o[6]
* pin cmd_o[1]
* pin dq_i[5]
* pin cmd_o[20]
* pin dq_o[7]
* pin cmd_o[2]
* pin dq_i[1]
* pin dq_i[6]
* pin cmd_o[3]
* pin cmd_o[4]
* pin dq_oe
* pin cmd_o[5]
* pin cmd_o[0]
* pin dq_o[4]
* pin dq_o[3]
* pin dq_o[0]
* pin ck_o
* pin dq_i[0]
* pin dq_o[6]
* pin dq_o[5]
* pin dq_o[2]
* pin dq_o[1]
.SUBCKT sdram_phy_core dq_i[4] cmd_o[12] cmd_o[11] dq_i[3] VDD$1 VSS$1
+ cmd_o[16] cmd_o[7] cmd_o[15] cmd_o[9] cmd_o[14] cmd_o[17] cmd_o[18] cmd_o[10]
+ dq_i[2] cmd_o[13] cmd_o[8] cmd_o[19] dq_i[7] cmd_o[6] cmd_o[1] dq_i[5]
+ cmd_o[20] dq_o[7] cmd_o[2] dq_i[1] dq_i[6] cmd_o[3] cmd_o[4] dq_oe cmd_o[5]
+ cmd_o[0] dq_o[4] dq_o[3] dq_o[0] ck_o dq_i[0] dq_o[6] dq_o[5] dq_o[2] dq_o[1]
.ENDS sdram_phy_core

* cell gf180_pad_core
* pin
* pin IN
* pin VDDIO
* pin
* pin
* pin
* pin
* pin
* pin
* pin
* pin
* pin PAD
* pin
* pin
* pin
* pin
* pin
* pin
* pin
* pin
* pin
* pin
* pin
* pin OUT
* pin
* pin
* pin
* pin
* pin
* pin
* pin
* pin
* pin
* pin
* pin OE_N
* pin
* pin
* pin
* pin
* pin VSSIO
.SUBCKT gf180_pad_core \$2 IN VDDIO \$9 \$14 \$16 \$20 \$21 \$34 \$41 \$46 PAD
+ \$220 \$232 \$345 \$355 \$378 \$438 \$439 \$554 \$557 \$558 \$559 OUT \$575
+ \$576 \$581 \$582 \$586 \$588 \$589 \$591 \$592 \$595 OE_N \$616 \$625 \$629
+ \$630 VSSIO
* device instance $1 r0 *1 -39.42,47.5 pfet_03v3
M$1 \$440 GP VDDIO VDDIO pfet_03v3 L=0.28U W=200U AS=52.9P AD=52.9P PS=226.16U
+ PD=226.16U
* device instance $41 r0 *1 0.58,46 nfet_03v3
M$41 \$440 GN VSSIO VSSIO nfet_03v3 L=0.28U W=80U AS=21.16P AD=21.16P
+ PS=103.16U PD=103.16U
* device instance $81 r0 *1 36.7,0 ppolyf_u
R$81 \$440 PAD VSSIO 22.2727272727 ppolyf_u L=1.4U W=22U
* device instance $82 r0 *1 -50.16,14 diode_pd2nw_03v3
D$82 PAD VDDIO diode_pd2nw_03v3 A=64P P=32U
* device instance $83 r0 *1 -50.16,-6 diode_nd2ps_03v3
D$83 VSSIO PAD diode_nd2ps_03v3 A=128P P=64U
* device instance $85 r0 *1 -49.16,-33 diode_pd2nw_03v3
D$85 VSSIO VDDIO diode_pd2nw_03v3 A=100P P=40U
* device instance $86 r0 *1 -9.42,-49 nfet_03v3
M$86 IN PAD VSSIO VSSIO nfet_03v3 L=0.28U W=2U AS=0.88P AD=0.88P PS=4.88U
+ PD=4.88U
* device instance $87 r0 *1 -9.42,-60 pfet_03v3
M$87 IN PAD VDDIO VDDIO pfet_03v3 L=0.28U W=4U AS=1.76P AD=1.76P PS=8.88U
+ PD=8.88U
* device instance $88 r0 *1 -31,56.4 pfet_03v3
M$88 \$600 OUT VDDIO VDDIO pfet_03v3 L=0.28U W=2U AS=0.88P AD=0.88P PS=4.88U
+ PD=4.88U
* device instance $89 r0 *1 -31,60.1 nfet_03v3
M$89 \$600 OUT VSSIO VSSIO nfet_03v3 L=0.28U W=1U AS=0.44P AD=0.44P PS=2.88U
+ PD=2.88U
* device instance $90 r0 *1 -27,56.4 pfet_03v3
M$90 \$601 OE_N VDDIO VDDIO pfet_03v3 L=0.28U W=2U AS=0.88P AD=0.88P PS=4.88U
+ PD=4.88U
* device instance $91 r0 *1 -27,60.1 nfet_03v3
M$91 \$601 OE_N VSSIO VSSIO nfet_03v3 L=0.28U W=1U AS=0.44P AD=0.44P PS=2.88U
+ PD=2.88U
* device instance $92 r0 *1 -23,56.4 pfet_03v3
M$92 \$571 PU_OK VDDIO VDDIO pfet_03v3 L=0.28U W=2U AS=0.88P AD=0.88P PS=4.88U
+ PD=4.88U
* device instance $93 r0 *1 -19.9,56.4 pfet_03v3
M$93 \$571 \$601 VDDIO VDDIO pfet_03v3 L=0.28U W=2U AS=0.88P AD=0.88P PS=4.88U
+ PD=4.88U
* device instance $94 m90 *1 -24.16,60.1 nfet_03v3
M$94 \$571 PU_OK \$602 VSSIO nfet_03v3 L=0.28U W=1U AS=0.44P AD=0.44P PS=2.88U
+ PD=2.88U
* device instance $95 m90 *1 -21.06,60.1 nfet_03v3
M$95 \$602 \$601 VSSIO VSSIO nfet_03v3 L=0.28U W=1U AS=0.44P AD=0.44P PS=2.88U
+ PD=2.88U
* device instance $96 r0 *1 -16,56.4 pfet_03v3
M$96 \$603 \$571 VDDIO VDDIO pfet_03v3 L=0.28U W=2U AS=0.88P AD=0.88P PS=4.88U
+ PD=4.88U
* device instance $97 r0 *1 -12.9,56.4 pfet_03v3
M$97 \$604 \$600 \$603 VDDIO pfet_03v3 L=0.28U W=2U AS=0.88P AD=0.88P PS=4.88U
+ PD=4.88U
* device instance $98 r0 *1 -16,60.1 nfet_03v3
M$98 \$604 \$571 VSSIO VSSIO nfet_03v3 L=0.28U W=1U AS=0.44P AD=0.44P PS=2.88U
+ PD=2.88U
* device instance $99 r0 *1 -12.9,60.1 nfet_03v3
M$99 \$604 \$600 VSSIO VSSIO nfet_03v3 L=0.28U W=1U AS=0.44P AD=0.44P PS=2.88U
+ PD=2.88U
* device instance $100 r0 *1 -9,56.4 pfet_03v3
M$100 \$605 \$604 VDDIO VDDIO pfet_03v3 L=0.28U W=2U AS=0.88P AD=0.88P PS=4.88U
+ PD=4.88U
* device instance $101 r0 *1 -9,60.1 nfet_03v3
M$101 \$605 \$604 VSSIO VSSIO nfet_03v3 L=0.28U W=1U AS=0.44P AD=0.44P PS=2.88U
+ PD=2.88U
* device instance $102 r0 *1 -5,56.4 pfet_03v3
M$102 \$606 \$605 VDDIO VDDIO pfet_03v3 L=0.28U W=2U AS=0.88P AD=0.88P PS=4.88U
+ PD=4.88U
* device instance $103 r0 *1 -5,60.1 nfet_03v3
M$103 \$606 \$605 VSSIO VSSIO nfet_03v3 L=0.28U W=1U AS=0.44P AD=0.44P PS=2.88U
+ PD=2.88U
* device instance $104 r0 *1 -1,56.4 pfet_03v3
M$104 GP \$606 VDDIO VDDIO pfet_03v3 L=0.28U W=2U AS=0.88P AD=0.88P PS=4.88U
+ PD=4.88U
* device instance $105 r0 *1 -1,60.1 nfet_03v3
M$105 GP \$606 VSSIO VSSIO nfet_03v3 L=0.28U W=1U AS=0.44P AD=0.44P PS=2.88U
+ PD=2.88U
* device instance $106 r0 *1 3,56.4 pfet_03v3
M$106 \$607 \$571 VDDIO VDDIO pfet_03v3 L=0.28U W=2U AS=0.88P AD=0.88P PS=4.88U
+ PD=4.88U
* device instance $107 r0 *1 6.1,56.4 pfet_03v3
M$107 \$608 OUT \$607 VDDIO pfet_03v3 L=0.28U W=2U AS=0.88P AD=0.88P PS=4.88U
+ PD=4.88U
* device instance $108 r0 *1 3,60.1 nfet_03v3
M$108 \$608 \$571 VSSIO VSSIO nfet_03v3 L=0.28U W=1U AS=0.44P AD=0.44P PS=2.88U
+ PD=2.88U
* device instance $109 r0 *1 6.1,60.1 nfet_03v3
M$109 \$608 OUT VSSIO VSSIO nfet_03v3 L=0.28U W=1U AS=0.44P AD=0.44P PS=2.88U
+ PD=2.88U
* device instance $110 r0 *1 10,56.4 pfet_03v3
M$110 \$609 \$608 VDDIO VDDIO pfet_03v3 L=0.28U W=2U AS=0.88P AD=0.88P PS=4.88U
+ PD=4.88U
* device instance $111 r0 *1 10,60.1 nfet_03v3
M$111 \$609 \$608 VSSIO VSSIO nfet_03v3 L=0.28U W=1U AS=0.44P AD=0.44P PS=2.88U
+ PD=2.88U
* device instance $112 r0 *1 14,56.4 pfet_03v3
M$112 GN \$609 VDDIO VDDIO pfet_03v3 L=0.28U W=2U AS=0.88P AD=0.88P PS=4.88U
+ PD=4.88U
* device instance $113 r0 *1 14,60.1 nfet_03v3
M$113 GN \$609 VSSIO VSSIO nfet_03v3 L=0.28U W=1U AS=0.44P AD=0.44P PS=2.88U
+ PD=2.88U
* device instance $114 r0 *1 0.58,82 nfet_03v3
M$114 PAD VSSIO VSSIO VSSIO nfet_03v3 L=0.28U W=160U AS=42.32P AD=42.32P
+ PS=185.16U PD=185.16U
.ENDS gf180_pad_core
