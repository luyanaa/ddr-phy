* Extracted by KLayout with GF180MCU LVS runset on : 28/11/2026 14:48

* cell gf180mcu_sdram_chip_top
.SUBCKT gf180mcu_sdram_chip_top
* cell instance $1 r0 *1 762.985,754.025
X$1 \$87977 VDDIO|VSS|VSSIO VDDIO|VSS|VSSIO VDDIO|VSS|VSSIO VDD VDDIO|VSS|VSSIO
+ \$14 VDDIO|VSS|VSSIO VDDIO|VSS|VSSIO VDDIO|VSS|VSSIO VDDIO|VSS|VSSIO
+ VDDIO|VSS|VSSIO VDDIO|VSS|VSSIO \$102059 VDDIO|VSS|VSSIO VDDIO|VSS|VSSIO
+ \$105670 \$103877 VDDIO|VSS|VSSIO VDDIO|VSS|VSSIO VDDIO|VSS|VSSIO
+ VDDIO|VSS|VSSIO \$109984 \$110833 VDDIO|VSS|VSSIO VDDIO|VSS|VSSIO \$116310
+ VDDIO|VSS|VSSIO VDDIO|VSS|VSSIO \$117925 \$117928 VDDIO|VSS|VSSIO
+ VDDIO|VSS|VSSIO VDDIO|VSS|VSSIO VDDIO|VSS|VSSIO VDDIO|VSS|VSSIO
+ VDDIO|VSS|VSSIO VDDIO|VSS|VSSIO \$124349 VDDIO|VSS|VSSIO VDDIO|VSS|VSSIO
+ sdram_phy_core
* cell instance $2 r0 *1 1042.02,985.995
X$2 VDD VDDIO|VSS|VSSIO VDDIO|VSS|VSSIO \$117925 gf180mcu_as_sc_mcu7t3v3__inv_2
* cell instance $21 r270 *1 25,1108.16
X$21 \$I287 \$I255 \$I323 VDDIO|VSS|VSSIO VDDIO|VSS|VSSIO \$129808
+ gf180_pad_tile
* cell instance $25 r270 *1 25,918.16
X$25 \$I289 \$I257 \$I325 VDDIO|VSS|VSSIO VDDIO|VSS|VSSIO \$104031
+ gf180_pad_tile
* cell instance $29 r270 *1 25,1488.16
X$29 \$I288 \$I256 \$I324 VDDIO|VSS|VSSIO VDDIO|VSS|VSSIO \$190609
+ gf180_pad_tile
* cell instance $41 r90 *1 1775,975.16
X$41 \$87977 \$I238 \$I307 VDDIO|VSS|VSSIO VDDIO|VSS|VSSIO \$129802
+ gf180_pad_tile
* cell instance $43 r90 *1 1775,1355.16
X$43 \$116310 \$I243 \$I312 VDDIO|VSS|VSSIO VDDIO|VSS|VSSIO \$190603
+ gf180_pad_tile
* cell instance $54 r90 *1 1775,1165.16
X$54 VDDIO|VSS|VSSIO \$I239 \$I308 VDDIO|VSS|VSSIO VDDIO|VSS|VSSIO \$160893
+ gf180_pad_tile
* cell instance $59 r180 *1 586.5,1775
X$59 \$I285 \$I253 \$I321 VDDIO|VSS|VSSIO VDDIO|VSS|VSSIO \$213599
+ gf180_pad_tile
* cell instance $63 r180 *1 966.5,1775
X$63 \$I277 \$I245 \$I314 VDDIO|VSS|VSSIO VDDIO|VSS|VSSIO \$213831
+ gf180_pad_tile
* cell instance $69 r0 *1 1213.5,25
X$69 \$I268 \$I235 \$I304 VDDIO|VSS|VSSIO VDDIO|VSS|VSSIO \$19 gf180_pad_tile
* cell instance $72 r90 *1 1775,595.16
X$72 VDDIO|VSS|VSSIO \$I241 \$I310 VDDIO|VSS|VSSIO VDDIO|VSS|VSSIO \$79173
+ gf180_pad_tile
* cell instance $78 r0 *1 1023.5,25
X$78 \$I269 VDDIO|VSS|VSSIO \$I305 VDDIO|VSS|VSSIO VDDIO|VSS|VSSIO \$21
+ gf180_pad_tile
* cell instance $95 r90 *1 1775,405.16
X$95 VDDIO|VSS|VSSIO \$I242 \$I311 VDDIO|VSS|VSSIO VDDIO|VSS|VSSIO \$47625
+ gf180_pad_tile
* cell instance $103 r0 *1 263.5,25
X$103 \$I266 \$I234 \$I302 VDDIO|VSS|VSSIO VDDIO|VSS|VSSIO \$28 gf180_pad_tile
* cell instance $109 r0 *1 643.5,25
X$109 \$I267 VDDIO|VSS|VSSIO \$I303 VDDIO|VSS|VSSIO VDDIO|VSS|VSSIO \$33
+ gf180_pad_tile
* cell instance $112 r0 *1 453.5,25
X$112 \$I265 \$I233 \$I301 VDDIO|VSS|VSSIO VDDIO|VSS|VSSIO \$27 gf180_pad_tile
* cell instance $116 r270 *1 25,728.16
X$116 \$I292 \$I260 \$I328 VDDIO|VSS|VSSIO VDDIO|VSS|VSSIO \$79180
+ gf180_pad_tile
* cell instance $119 r270 *1 25,348.16
X$119 \$I290 VDDIO|VSS|VSSIO \$I326 VDDIO|VSS|VSSIO VDDIO|VSS|VSSIO \$16491
+ gf180_pad_tile
* cell instance $127 r270 *1 25,1298.16
X$127 \$I286 \$I254 \$I322 VDDIO|VSS|VSSIO VDDIO|VSS|VSSIO \$160899
+ gf180_pad_tile
* cell instance $128 r180 *1 396.5,1775
X$128 \$I284 \$I252 \$I320 VDDIO|VSS|VSSIO VDDIO|VSS|VSSIO \$213504
+ gf180_pad_tile
* cell instance $129 r180 *1 206.5,1775
X$129 \$I283 \$I251 \$I319 VDDIO|VSS|VSSIO VDDIO|VSS|VSSIO \$213416
+ gf180_pad_tile
* cell instance $130 r180 *1 776.5,1775
X$130 \$I282 \$I250 \$I318 VDDIO|VSS|VSSIO VDDIO|VSS|VSSIO \$213718
+ gf180_pad_tile
* cell instance $131 r180 *1 1536.5,1775
X$131 \$I280 \$I248 \$I317 VDDIO|VSS|VSSIO VDDIO|VSS|VSSIO \$214163
+ gf180_pad_tile
* cell instance $132 r180 *1 1346.5,1775
X$132 \$I279 \$I247 \$I316 VDDIO|VSS|VSSIO VDDIO|VSS|VSSIO \$214052
+ gf180_pad_tile
* cell instance $133 r0 *1 1403.5,25
X$133 \$I270 \$I237 \$I306 VDDIO|VSS|VSSIO VDDIO|VSS|VSSIO \$17 gf180_pad_tile
* cell instance $135 r0 *1 833.5,25
X$135 \$I264 \$I232 \$I300 VDDIO|VSS|VSSIO VDDIO|VSS|VSSIO \$25 gf180_pad_tile
* cell instance $138 r90 *1 1775,215.16
X$138 VDDIO|VSS|VSSIO \$I244 \$I313 VDDIO|VSS|VSSIO VDDIO|VSS|VSSIO \$16484
+ gf180_pad_tile
* cell instance $147 r180 *1 1726.5,1775
X$147 VDDIO|VSS|VSSIO \$I249 VDDIO|VSS|VSSIO VDDIO|VSS|VSSIO VDDIO|VSS|VSSIO
+ \$214217 gf180_pad_tile
* cell instance $153 r180 *1 1156.5,1775
X$153 \$I278 \$I246 \$I315 VDDIO|VSS|VSSIO VDDIO|VSS|VSSIO \$213951
+ gf180_pad_tile
* cell instance $167 r90 *1 1775,785.16
X$167 VDDIO|VSS|VSSIO \$I240 \$I309 VDDIO|VSS|VSSIO VDDIO|VSS|VSSIO \$104024
+ gf180_pad_tile
* cell instance $178 r270 *1 25,538.16
X$178 \$I291 \$I259 \$I327 VDDIO|VSS|VSSIO VDDIO|VSS|VSSIO \$47631
+ gf180_pad_tile
.ENDS gf180mcu_sdram_chip_top

* cell gf180mcu_as_sc_mcu7t3v3__inv_2
* pin VDD,VNW
* pin VPW,VSS
* pin Y
* pin A
.SUBCKT gf180mcu_as_sc_mcu7t3v3__inv_2 VDD|VNW VPW|VSS Y A
.ENDS gf180mcu_as_sc_mcu7t3v3__inv_2

* cell gf180_pad_tile
* pin IN
* pin OUT
* pin OE_N
* pin PU_OK,VDDIO
* pin VSSIO
* pin PAD
.SUBCKT gf180_pad_tile IN OUT OE_N PU_OK|VDDIO VSSIO PAD
.ENDS gf180_pad_tile

* cell sdram_phy_core
* pin dq_i[4]
* pin cmd_o[12]
* pin cmd_o[11]
* pin dq_i[3]
* pin VDD
* pin VSS
* pin cmd_o[16]
* pin cmd_o[7]
* pin cmd_o[15]
* pin cmd_o[9]
* pin cmd_o[14]
* pin cmd_o[17]
* pin cmd_o[18]
* pin cmd_o[10]
* pin dq_i[2]
* pin cmd_o[13]
* pin cmd_o[8]
* pin cmd_o[19]
* pin dq_i[7]
* pin cmd_o[6]
* pin cmd_o[1]
* pin dq_i[5]
* pin cmd_o[20]
* pin dq_o[7]
* pin cmd_o[2]
* pin dq_i[1]
* pin dq_i[6]
* pin cmd_o[3]
* pin cmd_o[4]
* pin dq_oe
* pin cmd_o[5]
* pin cmd_o[0]
* pin dq_o[4]
* pin dq_o[3]
* pin dq_o[0]
* pin ck_o
* pin dq_i[0]
* pin dq_o[6]
* pin dq_o[5]
* pin dq_o[2]
* pin dq_o[1]
.SUBCKT sdram_phy_core dq_i[4] cmd_o[12] cmd_o[11] dq_i[3] VDD$1 VSS$1
+ cmd_o[16] cmd_o[7] cmd_o[15] cmd_o[9] cmd_o[14] cmd_o[17] cmd_o[18] cmd_o[10]
+ dq_i[2] cmd_o[13] cmd_o[8] cmd_o[19] dq_i[7] cmd_o[6] cmd_o[1] dq_i[5]
+ cmd_o[20] dq_o[7] cmd_o[2] dq_i[1] dq_i[6] cmd_o[3] cmd_o[4] dq_oe cmd_o[5]
+ cmd_o[0] dq_o[4] dq_o[3] dq_o[0] ck_o dq_i[0] dq_o[6] dq_o[5] dq_o[2] dq_o[1]
.ENDS sdram_phy_core
