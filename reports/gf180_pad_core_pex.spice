* SPICE3 file created from gf180_pad_core_flat.ext - technology: gf180mcuD

.option scale=5n

.subckt gf180_pad_core_flat GP GN PAD VSSIO VDDIO IN OUT OE_N PU_OK
X0 a_n7856_9000.t57 GP.t25 VDDIO.t49 VDDIO.t48 pfet_03v3 ad=52n pd=1.104m as=52n ps=1.104m w=1000 l=56
X1 VSSIO.t107 VSSIO.t105 PAD.t28 VSSIO.t106 nfet_03v3 ad=20.8n pd=0.504m as=20.8n ps=0.504m w=400 l=56
X2 VSSIO.t53 VSSIO.t51 PAD.t33 VSSIO.t52 nfet_03v3 ad=20.8n pd=0.504m as=20.8n ps=0.504m w=400 l=56
X3 PAD.t17 VSSIO.t6 VSSIO.t8 VSSIO.t7 nfet_03v3 ad=20.8n pd=0.504m as=20.8n ps=0.504m w=400 l=56
X4 VSSIO.t217 GN.t2 a_n7856_9000.t40 VSSIO.t216 nfet_03v3 ad=35.2n pd=0.976m as=20.8n ps=0.504m w=400 l=56
X5 PAD.t1 VSSIO.t66 VSSIO.t68 VSSIO.t67 nfet_03v3 ad=20.8n pd=0.504m as=20.8n ps=0.504m w=400 l=56
X6 PAD.t32 VSSIO.t42 VSSIO.t44 VSSIO.t43 nfet_03v3 ad=20.8n pd=0.504m as=20.8n ps=0.504m w=400 l=56
X7 a_n7856_9000.t17 GN.t25 VSSIO.t171 VSSIO.t170 nfet_03v3 ad=20.8n pd=0.504m as=20.8n ps=0.504m w=400 l=56
X8 VDDIO.t93 GP.t2 a_n7856_9000.t80 VDDIO.t92 pfet_03v3 ad=88n pd=2.176m as=52n ps=1.104m w=1000 l=56
X9 VDDIO.t37 GP.t32 a_n7856_9000.t50 VDDIO.t36 pfet_03v3 ad=52n pd=1.104m as=52n ps=1.104m w=1000 l=56
X10 a_n4804_11920.t0 PU_OK.t1 a_n4948_11920.t1 VSSIO.t121 nfet_03v3 ad=17.6n pd=0.576m as=17.6n ps=0.576m w=200 l=56
X11 a_n3172_11920.t2 a_n6172_11080.t2 a_n3172_11080.t1 VDDIO.t13 pfet_03v3 ad=35.2n pd=0.976m as=35.2n ps=0.976m w=400 l=56
X12 a_n7856_9000.t51 GP.t31 VDDIO.t39 VDDIO.t38 pfet_03v3 ad=52n pd=1.104m as=52n ps=1.104m w=1000 l=56
X13 VSSIO.t187 GN.t18 a_n7856_9000.t24 VSSIO.t186 nfet_03v3 ad=20.8n pd=0.504m as=20.8n ps=0.504m w=400 l=56
X14 a_n7856_9000.t73 GP.t9 VDDIO.t81 VDDIO.t80 pfet_03v3 ad=52n pd=1.104m as=52n ps=1.104m w=1000 l=56
X15 VSSIO.t137 a_n5372_11080.t3 a_n4804_11920.t1 VSSIO.t136 nfet_03v3 ad=17.6n pd=0.576m as=17.6n ps=0.576m w=200 l=56
X16 VSSIO.t195 GN.t16 a_n7856_9000.t26 VSSIO.t194 nfet_03v3 ad=20.8n pd=0.504m as=20.8n ps=0.504m w=400 l=56
X17 a_n3172_11920.t0 a_n6172_11080.t3 VSSIO.t125 VSSIO.t124 nfet_03v3 ad=17.6n pd=0.576m as=17.6n ps=0.576m w=200 l=56
X18 VSSIO.t41 VSSIO.t39 PAD.t20 VSSIO.t40 nfet_03v3 ad=20.8n pd=0.504m as=20.8n ps=0.504m w=400 l=56
X19 a_n7856_9000.t43 GP.t39 VDDIO.t23 VDDIO.t22 pfet_03v3 ad=52n pd=1.104m as=52n ps=1.104m w=1000 l=56
X20 VSSIO.t101 VSSIO.t99 PAD.t35 VSSIO.t100 nfet_03v3 ad=20.8n pd=0.504m as=20.8n ps=0.504m w=400 l=56
X21 PAD.t2 VSSIO.t0 VSSIO.t2 VSSIO.t1 nfet_03v3 ad=20.8n pd=0.504m as=35.2n ps=0.976m w=400 l=56
X22 a_n7856_9000.t23 GN.t19 VSSIO.t185 VSSIO.t184 nfet_03v3 ad=20.8n pd=0.504m as=20.8n ps=0.504m w=400 l=56
X23 VDDIO.t87 GP.t8 a_n7856_9000.t74 VDDIO.t86 pfet_03v3 ad=52n pd=1.104m as=52n ps=1.104m w=1000 l=56
X24 a_n972_11080.t1 a_n1772_11080.t2 VDDIO.t103 VDDIO.t102 pfet_03v3 ad=35.2n pd=0.976m as=35.2n ps=0.976m w=400 l=56
X25 PAD.t14 VSSIO.t90 VSSIO.t92 VSSIO.t91 nfet_03v3 ad=20.8n pd=0.504m as=20.8n ps=0.504m w=400 l=56
X26 a_n7856_9000.t31 GN.t11 VSSIO.t189 VSSIO.t188 nfet_03v3 ad=20.8n pd=0.504m as=20.8n ps=0.504m w=400 l=56
X27 VDDIO.t25 GP.t38 a_n7856_9000.t44 VDDIO.t24 pfet_03v3 ad=52n pd=1.104m as=52n ps=1.104m w=1000 l=56
X28 VSSIO.t119 VSSIO.t117 PAD.t30 VSSIO.t118 nfet_03v3 ad=35.2n pd=0.976m as=20.8n ps=0.504m w=400 l=56
X29 a_n972_11080.t0 a_n1772_11080.t3 VSSIO.t229 VSSIO.t228 nfet_03v3 ad=17.6n pd=0.576m as=17.6n ps=0.576m w=200 l=56
X30 VSSIO.t193 GN.t12 a_n7856_9000.t30 VSSIO.t192 nfet_03v3 ad=20.8n pd=0.504m as=20.8n ps=0.504m w=400 l=56
X31 a_n7856_9000.t67 GP.t15 VDDIO.t73 VDDIO.t72 pfet_03v3 ad=52n pd=1.104m as=52n ps=1.104m w=1000 l=56
X32 PAD.t31 VSSIO.t108 VSSIO.t110 VSSIO.t109 nfet_03v3 ad=20.8n pd=0.504m as=20.8n ps=0.504m w=400 l=56
X33 a_n7856_9000.t65 GP.t17 VDDIO.t65 VDDIO.t64 pfet_03v3 ad=52n pd=1.104m as=52n ps=1.104m w=1000 l=56
X34 VSSIO.t173 GN.t10 a_n7856_9000.t32 VSSIO.t172 nfet_03v3 ad=20.8n pd=0.504m as=20.8n ps=0.504m w=400 l=56
D0 VSSIO.t232 VDDIO.t100 diode_pd2nw_03v3 pj=8000 area=4e+06
X35 VSSIO.t147 GN.t38 a_n7856_9000.t4 VSSIO.t146 nfet_03v3 ad=20.8n pd=0.504m as=20.8n ps=0.504m w=400 l=56
D1 VSSIO.t218 PAD.t44 diode_nd2ps_03v3 pj=6400 area=2.56e+06
X36 VSSIO.t47 VSSIO.t45 PAD.t0 VSSIO.t46 nfet_03v3 ad=20.8n pd=0.504m as=20.8n ps=0.504m w=400 l=56
X37 a_n7856_9000.t9 GN.t33 VSSIO.t157 VSSIO.t156 nfet_03v3 ad=20.8n pd=0.504m as=20.8n ps=0.504m w=400 l=56
X38 a_n7856_9000.t3 GN.t39 VSSIO.t139 VSSIO.t138 nfet_03v3 ad=20.8n pd=0.504m as=20.8n ps=0.504m w=400 l=56
X39 VDDIO.t57 GP.t22 a_n7856_9000.t60 VDDIO.t56 pfet_03v3 ad=52n pd=1.104m as=52n ps=1.104m w=1000 l=56
X40 a_n7856_9000.t37 GN.t5 VSSIO.t211 VSSIO.t210 nfet_03v3 ad=20.8n pd=0.504m as=20.8n ps=0.504m w=400 l=56
X41 VDDIO.t53 GP.t24 a_n7856_9000.t58 VDDIO.t52 pfet_03v3 ad=52n pd=1.104m as=52n ps=1.104m w=1000 l=56
X42 PAD.t6 VSSIO.t84 VSSIO.t86 VSSIO.t85 nfet_03v3 ad=20.8n pd=0.504m as=20.8n ps=0.504m w=400 l=56
X43 a_n7856_9000.t39 GN.t3 VSSIO.t205 VSSIO.t204 nfet_03v3 ad=20.8n pd=0.504m as=20.8n ps=0.504m w=400 l=56
X44 VSSIO.t153 GN.t34 a_n7856_9000.t8 VSSIO.t152 nfet_03v3 ad=20.8n pd=0.504m as=20.8n ps=0.504m w=400 l=56
X45 a_n7856_9000.t61 GP.t21 VDDIO.t59 VDDIO.t58 pfet_03v3 ad=52n pd=1.104m as=52n ps=1.104m w=1000 l=56
X46 VSSIO.t77 VSSIO.t75 PAD.t23 VSSIO.t76 nfet_03v3 ad=20.8n pd=0.504m as=20.8n ps=0.504m w=400 l=56
X47 VSSIO.t215 GN.t4 a_n7856_9000.t38 VSSIO.t214 nfet_03v3 ad=20.8n pd=0.504m as=20.8n ps=0.504m w=400 l=56
X48 VSSIO.t169 GN.t26 a_n7856_9000.t16 VSSIO.t168 nfet_03v3 ad=20.8n pd=0.504m as=20.8n ps=0.504m w=400 l=56
X49 a_n7856_9000.t59 GP.t23 VDDIO.t55 VDDIO.t54 pfet_03v3 ad=52n pd=1.104m as=52n ps=1.104m w=1000 l=56
X50 IN.t0 PAD.t42 VSSIO.t223 VSSIO.t222 nfet_03v3 ad=35.2n pd=0.976m as=35.2n ps=0.976m w=400 l=56
X51 a_n7856_9000.t53 GP.t29 VDDIO.t33 VDDIO.t32 pfet_03v3 ad=52n pd=1.104m as=52n ps=1.104m w=1000 l=56
X52 PAD.t37 VSSIO.t102 VSSIO.t104 VSSIO.t103 nfet_03v3 ad=20.8n pd=0.504m as=20.8n ps=0.504m w=400 l=56
X53 VSSIO.t35 VSSIO.t33 PAD.t21 VSSIO.t34 nfet_03v3 ad=20.8n pd=0.504m as=20.8n ps=0.504m w=400 l=56
X54 a_n7856_9000.t15 GN.t27 VSSIO.t167 VSSIO.t166 nfet_03v3 ad=20.8n pd=0.504m as=20.8n ps=0.504m w=400 l=56
X55 VSSIO.t95 VSSIO.t93 PAD.t40 VSSIO.t94 nfet_03v3 ad=20.8n pd=0.504m as=20.8n ps=0.504m w=400 l=56
X56 VDDIO.t41 GP.t28 a_n7856_9000.t54 VDDIO.t40 pfet_03v3 ad=52n pd=1.104m as=52n ps=1.104m w=1000 l=56
X57 VDDIO.t35 GP.t30 a_n7856_9000.t52 VDDIO.t34 pfet_03v3 ad=52n pd=1.104m as=52n ps=1.104m w=1000 l=56
X58 PAD.t19 VSSIO.t24 VSSIO.t26 VSSIO.t25 nfet_03v3 ad=20.8n pd=0.504m as=20.8n ps=0.504m w=400 l=56
X59 VSSIO.t113 VSSIO.t111 PAD.t36 VSSIO.t112 nfet_03v3 ad=20.8n pd=0.504m as=20.8n ps=0.504m w=400 l=56
X60 VSSIO.t183 GN.t20 a_n7856_9000.t22 VSSIO.t182 nfet_03v3 ad=20.8n pd=0.504m as=20.8n ps=0.504m w=400 l=56
X61 a_n7856_9000.t75 GP.t7 VDDIO.t85 VDDIO.t84 pfet_03v3 ad=52n pd=1.104m as=52n ps=1.104m w=1000 l=56
X62 a_n1772_11080.t0 a_n3172_11920.t3 VDDIO.t12 VDDIO.t11 pfet_03v3 ad=35.2n pd=0.976m as=35.2n ps=0.976m w=400 l=56
X63 a_n7856_9000.t47 GP.t35 VDDIO.t27 VDDIO.t26 pfet_03v3 ad=52n pd=1.104m as=52n ps=1.104m w=1000 l=56
X64 a_n7856_9000.t45 GP.t37 VDDIO.t21 VDDIO.t20 pfet_03v3 ad=52n pd=1.104m as=52n ps=1.104m w=1000 l=56
X65 a_2028_11080.t1 a_628_11920.t3 VDDIO.t107 VDDIO.t106 pfet_03v3 ad=35.2n pd=0.976m as=35.2n ps=0.976m w=400 l=56
X66 VDDIO.t83 GP.t6 a_n7856_9000.t76 VDDIO.t82 pfet_03v3 ad=52n pd=1.104m as=52n ps=1.104m w=1000 l=56
X67 a_n1772_11080.t1 a_n3172_11920.t4 VSSIO.t231 VSSIO.t230 nfet_03v3 ad=17.6n pd=0.576m as=17.6n ps=0.576m w=200 l=56
X68 PAD.t24 VSSIO.t60 VSSIO.t62 VSSIO.t61 nfet_03v3 ad=20.8n pd=0.504m as=35.2n ps=0.976m w=400 l=56
X69 a_n7856_9000.t29 GN.t13 VSSIO.t197 VSSIO.t196 nfet_03v3 ad=20.8n pd=0.504m as=20.8n ps=0.504m w=400 l=56
X70 VDDIO.t19 GP.t36 a_n7856_9000.t46 VDDIO.t18 pfet_03v3 ad=52n pd=1.104m as=52n ps=1.104m w=1000 l=56
X71 VDDIO.t71 GP.t14 a_n7856_9000.t68 VDDIO.t70 pfet_03v3 ad=52n pd=1.104m as=52n ps=1.104m w=1000 l=56
X72 a_2028_11080.t0 a_628_11920.t4 VSSIO.t225 VSSIO.t224 nfet_03v3 ad=17.6n pd=0.576m as=17.6n ps=0.576m w=200 l=56
X73 a_n7856_9000.t1 GN.t41 VSSIO.t141 VSSIO.t140 nfet_03v3 ad=20.8n pd=0.504m as=35.2n ps=0.976m w=400 l=56
X74 PAD.t3 VSSIO.t18 VSSIO.t20 VSSIO.t19 nfet_03v3 ad=20.8n pd=0.504m as=20.8n ps=0.504m w=400 l=56
X75 PAD.t34 VSSIO.t78 VSSIO.t80 VSSIO.t79 nfet_03v3 ad=20.8n pd=0.504m as=20.8n ps=0.504m w=400 l=56
X76 VSSIO.t201 GN.t14 a_n7856_9000.t28 VSSIO.t200 nfet_03v3 ad=20.8n pd=0.504m as=20.8n ps=0.504m w=400 l=56
X77 a_n7856_9000.t69 GP.t13 VDDIO.t69 VDDIO.t68 pfet_03v3 ad=52n pd=1.104m as=52n ps=1.104m w=1000 l=56
X78 PAD.t11 VSSIO.t54 VSSIO.t56 VSSIO.t55 nfet_03v3 ad=20.8n pd=0.504m as=20.8n ps=0.504m w=400 l=56
X79 VSSIO.t11 VSSIO.t9 PAD.t25 VSSIO.t10 nfet_03v3 ad=20.8n pd=0.504m as=20.8n ps=0.504m w=400 l=56
X80 a_n4948_11920.t0 PU_OK.t0 VDDIO.t5 VDDIO.t4 pfet_03v3 ad=35.2n pd=0.976m as=35.2n ps=0.976m w=400 l=56
X81 a_n7856_9000.t41 GP.t41 VDDIO.t15 VDDIO.t14 pfet_03v3 ad=52n pd=1.104m as=88n ps=2.176m w=1000 l=56
X82 VSSIO.t143 GN.t40 a_n7856_9000.t2 VSSIO.t142 nfet_03v3 ad=20.8n pd=0.504m as=20.8n ps=0.504m w=400 l=56
X83 VSSIO.t71 VSSIO.t69 PAD.t5 VSSIO.t70 nfet_03v3 ad=20.8n pd=0.504m as=20.8n ps=0.504m w=400 l=56
X84 VSSIO.t213 GN.t6 a_n7856_9000.t36 VSSIO.t212 nfet_03v3 ad=20.8n pd=0.504m as=20.8n ps=0.504m w=400 l=56
X85 PAD.t15 VSSIO.t36 VSSIO.t38 VSSIO.t37 nfet_03v3 ad=20.8n pd=0.504m as=20.8n ps=0.504m w=400 l=56
X86 a_n7856_9000.t0 PAD.t9 VSSIO.t120 ppolyf_u r_width=4400 r_length=280
X87 a_n7856_9000.t7 GN.t35 VSSIO.t155 VSSIO.t154 nfet_03v3 ad=20.8n pd=0.504m as=20.8n ps=0.504m w=400 l=56
X88 a_n4948_11920.t2 a_n5372_11080.t2 VDDIO.t109 VDDIO.t108 pfet_03v3 ad=35.2n pd=0.976m as=35.2n ps=0.976m w=400 l=56
X89 PAD.t29 VSSIO.t96 VSSIO.t98 VSSIO.t97 nfet_03v3 ad=20.8n pd=0.504m as=20.8n ps=0.504m w=400 l=56
X90 VDDIO.t61 GP.t20 a_n7856_9000.t62 VDDIO.t60 pfet_03v3 ad=52n pd=1.104m as=52n ps=1.104m w=1000 l=56
X91 VSSIO.t29 VSSIO.t27 PAD.t4 VSSIO.t28 nfet_03v3 ad=20.8n pd=0.504m as=20.8n ps=0.504m w=400 l=56
X92 a_n7856_9000.t35 GN.t7 VSSIO.t209 VSSIO.t208 nfet_03v3 ad=20.8n pd=0.504m as=20.8n ps=0.504m w=400 l=56
X93 VSSIO.t89 VSSIO.t87 PAD.t38 VSSIO.t88 nfet_03v3 ad=20.8n pd=0.504m as=20.8n ps=0.504m w=400 l=56
X94 GN.t0 a_2028_11080.t2 VDDIO.t99 VDDIO.t98 pfet_03v3 ad=35.2n pd=0.976m as=35.2n ps=0.976m w=400 l=56
X95 VSSIO.t161 GN.t30 a_n7856_9000.t12 VSSIO.t160 nfet_03v3 ad=20.8n pd=0.504m as=20.8n ps=0.504m w=400 l=56
X96 VSSIO.t165 GN.t28 a_n7856_9000.t14 VSSIO.t164 nfet_03v3 ad=20.8n pd=0.504m as=20.8n ps=0.504m w=400 l=56
X97 GN.t1 a_2028_11080.t3 VSSIO.t227 VSSIO.t226 nfet_03v3 ad=17.6n pd=0.576m as=17.6n ps=0.576m w=200 l=56
X98 a_n7856_9000.t55 GP.t27 VDDIO.t43 VDDIO.t42 pfet_03v3 ad=52n pd=1.104m as=52n ps=1.104m w=1000 l=56
X99 VSSIO.t65 VSSIO.t63 PAD.t8 VSSIO.t64 nfet_03v3 ad=20.8n pd=0.504m as=20.8n ps=0.504m w=400 l=56
X100 a_n7856_9000.t13 GN.t29 VSSIO.t163 VSSIO.t162 nfet_03v3 ad=20.8n pd=0.504m as=20.8n ps=0.504m w=400 l=56
X101 a_n7856_9000.t19 GN.t23 VSSIO.t181 VSSIO.t180 nfet_03v3 ad=20.8n pd=0.504m as=20.8n ps=0.504m w=400 l=56
X102 a_n5372_11080.t1 OE_N.t0 VDDIO.t7 VDDIO.t6 pfet_03v3 ad=35.2n pd=0.976m as=35.2n ps=0.976m w=400 l=56
X103 a_628_11920.t2 OUT.t0 a_628_11080.t1 VDDIO.t10 pfet_03v3 ad=35.2n pd=0.976m as=35.2n ps=0.976m w=400 l=56
X104 VDDIO.t45 GP.t26 a_n7856_9000.t56 VDDIO.t44 pfet_03v3 ad=52n pd=1.104m as=52n ps=1.104m w=1000 l=56
X105 VDDIO.t89 GP.t4 a_n7856_9000.t78 VDDIO.t88 pfet_03v3 ad=52n pd=1.104m as=52n ps=1.104m w=1000 l=56
X106 a_n7856_9000.t21 GN.t21 VSSIO.t175 VSSIO.t174 nfet_03v3 ad=20.8n pd=0.504m as=20.8n ps=0.504m w=400 l=56
X107 VDDIO.t29 GP.t34 a_n7856_9000.t48 VDDIO.t28 pfet_03v3 ad=52n pd=1.104m as=52n ps=1.104m w=1000 l=56
X108 VSSIO.t83 VSSIO.t81 PAD.t27 VSSIO.t82 nfet_03v3 ad=20.8n pd=0.504m as=20.8n ps=0.504m w=400 l=56
D2 VSSIO.t220 PAD.t43 diode_nd2ps_03v3 pj=6400 area=2.56e+06
X109 VSSIO.t177 GN.t24 a_n7856_9000.t18 VSSIO.t176 nfet_03v3 ad=20.8n pd=0.504m as=20.8n ps=0.504m w=400 l=56
X110 a_n5372_11080.t0 OE_N.t1 VSSIO.t123 VSSIO.t122 nfet_03v3 ad=17.6n pd=0.576m as=17.6n ps=0.576m w=200 l=56
X111 a_628_11920.t1 OUT.t2 VSSIO.t131 VSSIO.t130 nfet_03v3 ad=17.6n pd=0.576m as=17.6n ps=0.576m w=200 l=56
X112 a_n7856_9000.t79 GP.t3 VDDIO.t91 VDDIO.t90 pfet_03v3 ad=52n pd=1.104m as=52n ps=1.104m w=1000 l=56
X113 VSSIO.t59 VSSIO.t57 PAD.t12 VSSIO.t58 nfet_03v3 ad=35.2n pd=0.976m as=20.8n ps=0.504m w=400 l=56
X114 PAD.t16 VSSIO.t12 VSSIO.t14 VSSIO.t13 nfet_03v3 ad=20.8n pd=0.504m as=20.8n ps=0.504m w=400 l=56
X115 VSSIO.t179 GN.t22 a_n7856_9000.t20 VSSIO.t178 nfet_03v3 ad=20.8n pd=0.504m as=20.8n ps=0.504m w=400 l=56
X116 a_n7856_9000.t77 GP.t5 VDDIO.t75 VDDIO.t74 pfet_03v3 ad=52n pd=1.104m as=52n ps=1.104m w=1000 l=56
X117 PAD.t18 VSSIO.t72 VSSIO.t74 VSSIO.t73 nfet_03v3 ad=20.8n pd=0.504m as=20.8n ps=0.504m w=400 l=56
X118 a_n7856_9000.t49 GP.t33 VDDIO.t31 VDDIO.t30 pfet_03v3 ad=52n pd=1.104m as=52n ps=1.104m w=1000 l=56
X119 PAD.t22 VSSIO.t48 VSSIO.t50 VSSIO.t49 nfet_03v3 ad=20.8n pd=0.504m as=20.8n ps=0.504m w=400 l=56
X120 VSSIO.t5 VSSIO.t3 PAD.t13 VSSIO.t4 nfet_03v3 ad=20.8n pd=0.504m as=20.8n ps=0.504m w=400 l=56
X121 PAD.t10 VSSIO.t30 VSSIO.t32 VSSIO.t31 nfet_03v3 ad=20.8n pd=0.504m as=20.8n ps=0.504m w=400 l=56
X122 a_n7856_9000.t25 GN.t17 VSSIO.t199 VSSIO.t198 nfet_03v3 ad=20.8n pd=0.504m as=20.8n ps=0.504m w=400 l=56
X123 VDDIO.t79 GP.t10 a_n7856_9000.t72 VDDIO.t78 pfet_03v3 ad=52n pd=1.104m as=52n ps=1.104m w=1000 l=56
X124 a_n7856_9000.t27 GN.t15 VSSIO.t191 VSSIO.t190 nfet_03v3 ad=20.8n pd=0.504m as=20.8n ps=0.504m w=400 l=56
X125 VDDIO.t47 GP.t12 a_n7856_9000.t70 VDDIO.t46 pfet_03v3 ad=52n pd=1.104m as=52n ps=1.104m w=1000 l=56
X126 VDDIO.t17 GP.t40 a_n7856_9000.t42 VDDIO.t16 pfet_03v3 ad=52n pd=1.104m as=52n ps=1.104m w=1000 l=56
X127 VSSIO.t23 VSSIO.t21 PAD.t7 VSSIO.t22 nfet_03v3 ad=20.8n pd=0.504m as=20.8n ps=0.504m w=400 l=56
X128 IN.t1 PAD.t41 VDDIO.t97 VDDIO.t96 pfet_03v3 ad=70.4n pd=1.776m as=70.4n ps=1.776m w=800 l=56
X129 a_n7856_9000.t71 GP.t11 VDDIO.t77 VDDIO.t76 pfet_03v3 ad=52n pd=1.104m as=52n ps=1.104m w=1000 l=56
X130 a_n6172_11080.t1 OUT.t1 VDDIO.t9 VDDIO.t8 pfet_03v3 ad=35.2n pd=0.976m as=35.2n ps=0.976m w=400 l=56
X131 a_n7856_9000.t63 GP.t19 VDDIO.t51 VDDIO.t50 pfet_03v3 ad=52n pd=1.104m as=52n ps=1.104m w=1000 l=56
X132 VSSIO.t207 GN.t8 a_n7856_9000.t34 VSSIO.t206 nfet_03v3 ad=20.8n pd=0.504m as=20.8n ps=0.504m w=400 l=56
X133 VSSIO.t151 GN.t36 a_n7856_9000.t6 VSSIO.t150 nfet_03v3 ad=20.8n pd=0.504m as=20.8n ps=0.504m w=400 l=56
X134 a_n6172_11080.t0 OUT.t3 VSSIO.t129 VSSIO.t128 nfet_03v3 ad=17.6n pd=0.576m as=17.6n ps=0.576m w=200 l=56
D3 PAD.t45 VDDIO.t94 diode_pd2nw_03v3 pj=6400 area=2.56e+06
X135 GP.t1 a_n972_11080.t2 VDDIO.t105 VDDIO.t104 pfet_03v3 ad=35.2n pd=0.976m as=35.2n ps=0.976m w=400 l=56
X136 VDDIO.t67 GP.t16 a_n7856_9000.t66 VDDIO.t66 pfet_03v3 ad=52n pd=1.104m as=52n ps=1.104m w=1000 l=56
X137 a_628_11080.t0 a_n4948_11920.t3 VDDIO.t1 VDDIO.t0 pfet_03v3 ad=35.2n pd=0.976m as=35.2n ps=0.976m w=400 l=56
X138 VDDIO.t63 GP.t18 a_n7856_9000.t64 VDDIO.t62 pfet_03v3 ad=52n pd=1.104m as=52n ps=1.104m w=1000 l=56
X139 a_n7856_9000.t33 GN.t9 VSSIO.t203 VSSIO.t202 nfet_03v3 ad=20.8n pd=0.504m as=20.8n ps=0.504m w=400 l=56
X140 a_n7856_9000.t11 GN.t31 VSSIO.t159 VSSIO.t158 nfet_03v3 ad=20.8n pd=0.504m as=20.8n ps=0.504m w=400 l=56
X141 a_n3172_11080.t0 a_n4948_11920.t4 VDDIO.t3 VDDIO.t2 pfet_03v3 ad=35.2n pd=0.976m as=35.2n ps=0.976m w=400 l=56
X142 a_n7856_9000.t5 GN.t37 VSSIO.t149 VSSIO.t148 nfet_03v3 ad=20.8n pd=0.504m as=20.8n ps=0.504m w=400 l=56
X143 GP.t0 a_n972_11080.t3 VSSIO.t133 VSSIO.t132 nfet_03v3 ad=17.6n pd=0.576m as=17.6n ps=0.576m w=200 l=56
X144 a_628_11920.t0 a_n4948_11920.t5 VSSIO.t127 VSSIO.t126 nfet_03v3 ad=17.6n pd=0.576m as=17.6n ps=0.576m w=200 l=56
X145 PAD.t39 VSSIO.t114 VSSIO.t116 VSSIO.t115 nfet_03v3 ad=20.8n pd=0.504m as=20.8n ps=0.504m w=400 l=56
X146 VSSIO.t17 VSSIO.t15 PAD.t26 VSSIO.t16 nfet_03v3 ad=20.8n pd=0.504m as=20.8n ps=0.504m w=400 l=56
X147 VSSIO.t145 GN.t32 a_n7856_9000.t10 VSSIO.t144 nfet_03v3 ad=20.8n pd=0.504m as=20.8n ps=0.504m w=400 l=56
X148 a_n3172_11920.t1 a_n4948_11920.t6 VSSIO.t135 VSSIO.t134 nfet_03v3 ad=17.6n pd=0.576m as=17.6n ps=0.576m w=200 l=56
R0 IN IN.t0 9.17375
R1 IN IN.t1 8.13509
R2 PAD.n117 PAD.t41 108.495
R3 PAD.n117 PAD.t42 75.5435
R4 PAD.n116 PAD.n96 10.6494
R5 PAD.n118 PAD.n117 10.1705
R6 PAD.n285 PAD 7.7513
R7 PAD.n106 PAD.n105 7.02725
R8 PAD.n93 PAD.n92 7.02725
R9 PAD.n84 PAD.n83 7.02725
R10 PAD.n116 PAD.n115 6.97229
R11 PAD.n115 PAD.n114 6.89675
R12 PAD.n113 PAD.n97 6.66725
R13 PAD.n112 PAD.n98 6.66725
R14 PAD.n111 PAD.n99 6.66725
R15 PAD.n110 PAD.n100 6.66725
R16 PAD.n109 PAD.n101 6.66725
R17 PAD.n108 PAD.n102 6.66725
R18 PAD.n107 PAD.n103 6.66725
R19 PAD.n106 PAD.n104 6.66725
R20 PAD.n93 PAD.n91 6.66725
R21 PAD.n94 PAD.n90 6.66725
R22 PAD.n95 PAD.n89 6.66725
R23 PAD.n88 PAD.n78 6.66725
R24 PAD.n87 PAD.n79 6.66725
R25 PAD.n86 PAD.n80 6.66725
R26 PAD.n85 PAD.n81 6.66725
R27 PAD.n84 PAD.n82 6.66725
R28 PAD.n287 PAD.n286 4.5005
R29 PAD.n288 PAD.n287 4.5005
R30 PAD.n287 PAD.n238 4.5005
R31 PAD.n287 PAD.n33 4.5005
R32 PAD.n287 PAD.n236 4.5005
R33 PAD.n287 PAD.n34 4.5005
R34 PAD.n287 PAD.n234 4.5005
R35 PAD.n287 PAD.n35 4.5005
R36 PAD.n287 PAD.n232 4.5005
R37 PAD.n287 PAD.n36 4.5005
R38 PAD.n287 PAD.n230 4.5005
R39 PAD.n287 PAD.n37 4.5005
R40 PAD.n287 PAD.n227 4.5005
R41 PAD.n287 PAD.n38 4.5005
R42 PAD.n287 PAD.n225 4.5005
R43 PAD.n287 PAD.n39 4.5005
R44 PAD.n287 PAD.n223 4.5005
R45 PAD.n287 PAD.n40 4.5005
R46 PAD.n287 PAD.n221 4.5005
R47 PAD.n287 PAD.n41 4.5005
R48 PAD.n287 PAD.n219 4.5005
R49 PAD.n287 PAD.n42 4.5005
R50 PAD.n287 PAD.n217 4.5005
R51 PAD.n287 PAD.n43 4.5005
R52 PAD.n287 PAD.n215 4.5005
R53 PAD.n287 PAD.n44 4.5005
R54 PAD.n287 PAD.n213 4.5005
R55 PAD.n287 PAD.n45 4.5005
R56 PAD.n287 PAD.n211 4.5005
R57 PAD.n287 PAD.n46 4.5005
R58 PAD.n287 PAD.n209 4.5005
R59 PAD.n287 PAD.n47 4.5005
R60 PAD.n288 PAD.n1 4.5005
R61 PAD.n238 PAD.n1 4.5005
R62 PAD.n33 PAD.n1 4.5005
R63 PAD.n236 PAD.n1 4.5005
R64 PAD.n34 PAD.n1 4.5005
R65 PAD.n234 PAD.n1 4.5005
R66 PAD.n35 PAD.n1 4.5005
R67 PAD.n232 PAD.n1 4.5005
R68 PAD.n36 PAD.n1 4.5005
R69 PAD.n230 PAD.n1 4.5005
R70 PAD.n37 PAD.n1 4.5005
R71 PAD.n227 PAD.n1 4.5005
R72 PAD.n38 PAD.n1 4.5005
R73 PAD.n225 PAD.n1 4.5005
R74 PAD.n39 PAD.n1 4.5005
R75 PAD.n223 PAD.n1 4.5005
R76 PAD.n40 PAD.n1 4.5005
R77 PAD.n221 PAD.n1 4.5005
R78 PAD.n41 PAD.n1 4.5005
R79 PAD.n219 PAD.n1 4.5005
R80 PAD.n42 PAD.n1 4.5005
R81 PAD.n217 PAD.n1 4.5005
R82 PAD.n43 PAD.n1 4.5005
R83 PAD.n215 PAD.n1 4.5005
R84 PAD.n44 PAD.n1 4.5005
R85 PAD.n213 PAD.n1 4.5005
R86 PAD.n45 PAD.n1 4.5005
R87 PAD.n211 PAD.n1 4.5005
R88 PAD.n46 PAD.n1 4.5005
R89 PAD.n209 PAD.n1 4.5005
R90 PAD.n47 PAD.n1 4.5005
R91 PAD.n286 PAD.n1 4.5005
R92 PAD.n288 PAD.n31 4.5005
R93 PAD.n238 PAD.n31 4.5005
R94 PAD.n33 PAD.n31 4.5005
R95 PAD.n236 PAD.n31 4.5005
R96 PAD.n34 PAD.n31 4.5005
R97 PAD.n234 PAD.n31 4.5005
R98 PAD.n35 PAD.n31 4.5005
R99 PAD.n232 PAD.n31 4.5005
R100 PAD.n36 PAD.n31 4.5005
R101 PAD.n230 PAD.n31 4.5005
R102 PAD.n37 PAD.n31 4.5005
R103 PAD.n227 PAD.n31 4.5005
R104 PAD.n38 PAD.n31 4.5005
R105 PAD.n225 PAD.n31 4.5005
R106 PAD.n39 PAD.n31 4.5005
R107 PAD.n223 PAD.n31 4.5005
R108 PAD.n40 PAD.n31 4.5005
R109 PAD.n221 PAD.n31 4.5005
R110 PAD.n41 PAD.n31 4.5005
R111 PAD.n219 PAD.n31 4.5005
R112 PAD.n42 PAD.n31 4.5005
R113 PAD.n217 PAD.n31 4.5005
R114 PAD.n43 PAD.n31 4.5005
R115 PAD.n215 PAD.n31 4.5005
R116 PAD.n44 PAD.n31 4.5005
R117 PAD.n213 PAD.n31 4.5005
R118 PAD.n45 PAD.n31 4.5005
R119 PAD.n211 PAD.n31 4.5005
R120 PAD.n46 PAD.n31 4.5005
R121 PAD.n209 PAD.n31 4.5005
R122 PAD.n47 PAD.n31 4.5005
R123 PAD.n286 PAD.n31 4.5005
R124 PAD.n288 PAD.n2 4.5005
R125 PAD.n238 PAD.n2 4.5005
R126 PAD.n33 PAD.n2 4.5005
R127 PAD.n236 PAD.n2 4.5005
R128 PAD.n34 PAD.n2 4.5005
R129 PAD.n234 PAD.n2 4.5005
R130 PAD.n35 PAD.n2 4.5005
R131 PAD.n232 PAD.n2 4.5005
R132 PAD.n36 PAD.n2 4.5005
R133 PAD.n230 PAD.n2 4.5005
R134 PAD.n37 PAD.n2 4.5005
R135 PAD.n227 PAD.n2 4.5005
R136 PAD.n38 PAD.n2 4.5005
R137 PAD.n225 PAD.n2 4.5005
R138 PAD.n39 PAD.n2 4.5005
R139 PAD.n223 PAD.n2 4.5005
R140 PAD.n40 PAD.n2 4.5005
R141 PAD.n221 PAD.n2 4.5005
R142 PAD.n41 PAD.n2 4.5005
R143 PAD.n219 PAD.n2 4.5005
R144 PAD.n42 PAD.n2 4.5005
R145 PAD.n217 PAD.n2 4.5005
R146 PAD.n43 PAD.n2 4.5005
R147 PAD.n215 PAD.n2 4.5005
R148 PAD.n44 PAD.n2 4.5005
R149 PAD.n213 PAD.n2 4.5005
R150 PAD.n45 PAD.n2 4.5005
R151 PAD.n211 PAD.n2 4.5005
R152 PAD.n46 PAD.n2 4.5005
R153 PAD.n209 PAD.n2 4.5005
R154 PAD.n47 PAD.n2 4.5005
R155 PAD.n286 PAD.n2 4.5005
R156 PAD.n288 PAD.n30 4.5005
R157 PAD.n238 PAD.n30 4.5005
R158 PAD.n33 PAD.n30 4.5005
R159 PAD.n236 PAD.n30 4.5005
R160 PAD.n34 PAD.n30 4.5005
R161 PAD.n234 PAD.n30 4.5005
R162 PAD.n35 PAD.n30 4.5005
R163 PAD.n232 PAD.n30 4.5005
R164 PAD.n36 PAD.n30 4.5005
R165 PAD.n230 PAD.n30 4.5005
R166 PAD.n37 PAD.n30 4.5005
R167 PAD.n227 PAD.n30 4.5005
R168 PAD.n38 PAD.n30 4.5005
R169 PAD.n225 PAD.n30 4.5005
R170 PAD.n39 PAD.n30 4.5005
R171 PAD.n223 PAD.n30 4.5005
R172 PAD.n40 PAD.n30 4.5005
R173 PAD.n221 PAD.n30 4.5005
R174 PAD.n41 PAD.n30 4.5005
R175 PAD.n219 PAD.n30 4.5005
R176 PAD.n42 PAD.n30 4.5005
R177 PAD.n217 PAD.n30 4.5005
R178 PAD.n43 PAD.n30 4.5005
R179 PAD.n215 PAD.n30 4.5005
R180 PAD.n44 PAD.n30 4.5005
R181 PAD.n213 PAD.n30 4.5005
R182 PAD.n45 PAD.n30 4.5005
R183 PAD.n211 PAD.n30 4.5005
R184 PAD.n46 PAD.n30 4.5005
R185 PAD.n209 PAD.n30 4.5005
R186 PAD.n47 PAD.n30 4.5005
R187 PAD.n286 PAD.n30 4.5005
R188 PAD.n288 PAD.n3 4.5005
R189 PAD.n238 PAD.n3 4.5005
R190 PAD.n33 PAD.n3 4.5005
R191 PAD.n236 PAD.n3 4.5005
R192 PAD.n34 PAD.n3 4.5005
R193 PAD.n234 PAD.n3 4.5005
R194 PAD.n35 PAD.n3 4.5005
R195 PAD.n232 PAD.n3 4.5005
R196 PAD.n36 PAD.n3 4.5005
R197 PAD.n230 PAD.n3 4.5005
R198 PAD.n37 PAD.n3 4.5005
R199 PAD.n227 PAD.n3 4.5005
R200 PAD.n38 PAD.n3 4.5005
R201 PAD.n225 PAD.n3 4.5005
R202 PAD.n39 PAD.n3 4.5005
R203 PAD.n223 PAD.n3 4.5005
R204 PAD.n40 PAD.n3 4.5005
R205 PAD.n221 PAD.n3 4.5005
R206 PAD.n41 PAD.n3 4.5005
R207 PAD.n219 PAD.n3 4.5005
R208 PAD.n42 PAD.n3 4.5005
R209 PAD.n217 PAD.n3 4.5005
R210 PAD.n43 PAD.n3 4.5005
R211 PAD.n215 PAD.n3 4.5005
R212 PAD.n44 PAD.n3 4.5005
R213 PAD.n213 PAD.n3 4.5005
R214 PAD.n45 PAD.n3 4.5005
R215 PAD.n211 PAD.n3 4.5005
R216 PAD.n46 PAD.n3 4.5005
R217 PAD.n209 PAD.n3 4.5005
R218 PAD.n47 PAD.n3 4.5005
R219 PAD.n286 PAD.n3 4.5005
R220 PAD.n288 PAD.n29 4.5005
R221 PAD.n238 PAD.n29 4.5005
R222 PAD.n33 PAD.n29 4.5005
R223 PAD.n236 PAD.n29 4.5005
R224 PAD.n34 PAD.n29 4.5005
R225 PAD.n234 PAD.n29 4.5005
R226 PAD.n35 PAD.n29 4.5005
R227 PAD.n232 PAD.n29 4.5005
R228 PAD.n36 PAD.n29 4.5005
R229 PAD.n230 PAD.n29 4.5005
R230 PAD.n37 PAD.n29 4.5005
R231 PAD.n227 PAD.n29 4.5005
R232 PAD.n38 PAD.n29 4.5005
R233 PAD.n225 PAD.n29 4.5005
R234 PAD.n39 PAD.n29 4.5005
R235 PAD.n223 PAD.n29 4.5005
R236 PAD.n40 PAD.n29 4.5005
R237 PAD.n221 PAD.n29 4.5005
R238 PAD.n41 PAD.n29 4.5005
R239 PAD.n219 PAD.n29 4.5005
R240 PAD.n42 PAD.n29 4.5005
R241 PAD.n217 PAD.n29 4.5005
R242 PAD.n43 PAD.n29 4.5005
R243 PAD.n215 PAD.n29 4.5005
R244 PAD.n44 PAD.n29 4.5005
R245 PAD.n213 PAD.n29 4.5005
R246 PAD.n45 PAD.n29 4.5005
R247 PAD.n211 PAD.n29 4.5005
R248 PAD.n46 PAD.n29 4.5005
R249 PAD.n209 PAD.n29 4.5005
R250 PAD.n47 PAD.n29 4.5005
R251 PAD.n286 PAD.n29 4.5005
R252 PAD.n288 PAD.n4 4.5005
R253 PAD.n238 PAD.n4 4.5005
R254 PAD.n33 PAD.n4 4.5005
R255 PAD.n236 PAD.n4 4.5005
R256 PAD.n34 PAD.n4 4.5005
R257 PAD.n234 PAD.n4 4.5005
R258 PAD.n35 PAD.n4 4.5005
R259 PAD.n232 PAD.n4 4.5005
R260 PAD.n36 PAD.n4 4.5005
R261 PAD.n230 PAD.n4 4.5005
R262 PAD.n37 PAD.n4 4.5005
R263 PAD.n227 PAD.n4 4.5005
R264 PAD.n38 PAD.n4 4.5005
R265 PAD.n225 PAD.n4 4.5005
R266 PAD.n39 PAD.n4 4.5005
R267 PAD.n223 PAD.n4 4.5005
R268 PAD.n40 PAD.n4 4.5005
R269 PAD.n221 PAD.n4 4.5005
R270 PAD.n41 PAD.n4 4.5005
R271 PAD.n219 PAD.n4 4.5005
R272 PAD.n42 PAD.n4 4.5005
R273 PAD.n217 PAD.n4 4.5005
R274 PAD.n43 PAD.n4 4.5005
R275 PAD.n215 PAD.n4 4.5005
R276 PAD.n44 PAD.n4 4.5005
R277 PAD.n213 PAD.n4 4.5005
R278 PAD.n45 PAD.n4 4.5005
R279 PAD.n211 PAD.n4 4.5005
R280 PAD.n46 PAD.n4 4.5005
R281 PAD.n209 PAD.n4 4.5005
R282 PAD.n47 PAD.n4 4.5005
R283 PAD.n286 PAD.n4 4.5005
R284 PAD.n288 PAD.n28 4.5005
R285 PAD.n238 PAD.n28 4.5005
R286 PAD.n33 PAD.n28 4.5005
R287 PAD.n236 PAD.n28 4.5005
R288 PAD.n34 PAD.n28 4.5005
R289 PAD.n234 PAD.n28 4.5005
R290 PAD.n35 PAD.n28 4.5005
R291 PAD.n232 PAD.n28 4.5005
R292 PAD.n36 PAD.n28 4.5005
R293 PAD.n230 PAD.n28 4.5005
R294 PAD.n37 PAD.n28 4.5005
R295 PAD.n227 PAD.n28 4.5005
R296 PAD.n38 PAD.n28 4.5005
R297 PAD.n225 PAD.n28 4.5005
R298 PAD.n39 PAD.n28 4.5005
R299 PAD.n223 PAD.n28 4.5005
R300 PAD.n40 PAD.n28 4.5005
R301 PAD.n221 PAD.n28 4.5005
R302 PAD.n41 PAD.n28 4.5005
R303 PAD.n219 PAD.n28 4.5005
R304 PAD.n42 PAD.n28 4.5005
R305 PAD.n217 PAD.n28 4.5005
R306 PAD.n43 PAD.n28 4.5005
R307 PAD.n215 PAD.n28 4.5005
R308 PAD.n44 PAD.n28 4.5005
R309 PAD.n213 PAD.n28 4.5005
R310 PAD.n45 PAD.n28 4.5005
R311 PAD.n211 PAD.n28 4.5005
R312 PAD.n46 PAD.n28 4.5005
R313 PAD.n209 PAD.n28 4.5005
R314 PAD.n47 PAD.n28 4.5005
R315 PAD.n286 PAD.n28 4.5005
R316 PAD.n288 PAD.n5 4.5005
R317 PAD.n238 PAD.n5 4.5005
R318 PAD.n33 PAD.n5 4.5005
R319 PAD.n236 PAD.n5 4.5005
R320 PAD.n34 PAD.n5 4.5005
R321 PAD.n234 PAD.n5 4.5005
R322 PAD.n35 PAD.n5 4.5005
R323 PAD.n232 PAD.n5 4.5005
R324 PAD.n36 PAD.n5 4.5005
R325 PAD.n230 PAD.n5 4.5005
R326 PAD.n37 PAD.n5 4.5005
R327 PAD.n227 PAD.n5 4.5005
R328 PAD.n38 PAD.n5 4.5005
R329 PAD.n225 PAD.n5 4.5005
R330 PAD.n39 PAD.n5 4.5005
R331 PAD.n223 PAD.n5 4.5005
R332 PAD.n40 PAD.n5 4.5005
R333 PAD.n221 PAD.n5 4.5005
R334 PAD.n41 PAD.n5 4.5005
R335 PAD.n219 PAD.n5 4.5005
R336 PAD.n42 PAD.n5 4.5005
R337 PAD.n217 PAD.n5 4.5005
R338 PAD.n43 PAD.n5 4.5005
R339 PAD.n215 PAD.n5 4.5005
R340 PAD.n44 PAD.n5 4.5005
R341 PAD.n213 PAD.n5 4.5005
R342 PAD.n45 PAD.n5 4.5005
R343 PAD.n211 PAD.n5 4.5005
R344 PAD.n46 PAD.n5 4.5005
R345 PAD.n209 PAD.n5 4.5005
R346 PAD.n47 PAD.n5 4.5005
R347 PAD.n286 PAD.n5 4.5005
R348 PAD.n288 PAD.n27 4.5005
R349 PAD.n238 PAD.n27 4.5005
R350 PAD.n33 PAD.n27 4.5005
R351 PAD.n236 PAD.n27 4.5005
R352 PAD.n34 PAD.n27 4.5005
R353 PAD.n234 PAD.n27 4.5005
R354 PAD.n35 PAD.n27 4.5005
R355 PAD.n232 PAD.n27 4.5005
R356 PAD.n36 PAD.n27 4.5005
R357 PAD.n230 PAD.n27 4.5005
R358 PAD.n37 PAD.n27 4.5005
R359 PAD.n227 PAD.n27 4.5005
R360 PAD.n38 PAD.n27 4.5005
R361 PAD.n225 PAD.n27 4.5005
R362 PAD.n39 PAD.n27 4.5005
R363 PAD.n223 PAD.n27 4.5005
R364 PAD.n40 PAD.n27 4.5005
R365 PAD.n221 PAD.n27 4.5005
R366 PAD.n41 PAD.n27 4.5005
R367 PAD.n219 PAD.n27 4.5005
R368 PAD.n42 PAD.n27 4.5005
R369 PAD.n217 PAD.n27 4.5005
R370 PAD.n43 PAD.n27 4.5005
R371 PAD.n215 PAD.n27 4.5005
R372 PAD.n44 PAD.n27 4.5005
R373 PAD.n213 PAD.n27 4.5005
R374 PAD.n45 PAD.n27 4.5005
R375 PAD.n211 PAD.n27 4.5005
R376 PAD.n46 PAD.n27 4.5005
R377 PAD.n209 PAD.n27 4.5005
R378 PAD.n47 PAD.n27 4.5005
R379 PAD.n286 PAD.n27 4.5005
R380 PAD.n288 PAD.n6 4.5005
R381 PAD.n238 PAD.n6 4.5005
R382 PAD.n33 PAD.n6 4.5005
R383 PAD.n236 PAD.n6 4.5005
R384 PAD.n34 PAD.n6 4.5005
R385 PAD.n234 PAD.n6 4.5005
R386 PAD.n35 PAD.n6 4.5005
R387 PAD.n232 PAD.n6 4.5005
R388 PAD.n36 PAD.n6 4.5005
R389 PAD.n230 PAD.n6 4.5005
R390 PAD.n37 PAD.n6 4.5005
R391 PAD.n227 PAD.n6 4.5005
R392 PAD.n38 PAD.n6 4.5005
R393 PAD.n225 PAD.n6 4.5005
R394 PAD.n39 PAD.n6 4.5005
R395 PAD.n223 PAD.n6 4.5005
R396 PAD.n40 PAD.n6 4.5005
R397 PAD.n221 PAD.n6 4.5005
R398 PAD.n41 PAD.n6 4.5005
R399 PAD.n219 PAD.n6 4.5005
R400 PAD.n42 PAD.n6 4.5005
R401 PAD.n217 PAD.n6 4.5005
R402 PAD.n43 PAD.n6 4.5005
R403 PAD.n215 PAD.n6 4.5005
R404 PAD.n44 PAD.n6 4.5005
R405 PAD.n213 PAD.n6 4.5005
R406 PAD.n45 PAD.n6 4.5005
R407 PAD.n211 PAD.n6 4.5005
R408 PAD.n46 PAD.n6 4.5005
R409 PAD.n209 PAD.n6 4.5005
R410 PAD.n47 PAD.n6 4.5005
R411 PAD.n286 PAD.n6 4.5005
R412 PAD.n288 PAD.n26 4.5005
R413 PAD.n238 PAD.n26 4.5005
R414 PAD.n33 PAD.n26 4.5005
R415 PAD.n236 PAD.n26 4.5005
R416 PAD.n34 PAD.n26 4.5005
R417 PAD.n234 PAD.n26 4.5005
R418 PAD.n35 PAD.n26 4.5005
R419 PAD.n232 PAD.n26 4.5005
R420 PAD.n36 PAD.n26 4.5005
R421 PAD.n230 PAD.n26 4.5005
R422 PAD.n37 PAD.n26 4.5005
R423 PAD.n227 PAD.n26 4.5005
R424 PAD.n38 PAD.n26 4.5005
R425 PAD.n225 PAD.n26 4.5005
R426 PAD.n39 PAD.n26 4.5005
R427 PAD.n223 PAD.n26 4.5005
R428 PAD.n40 PAD.n26 4.5005
R429 PAD.n221 PAD.n26 4.5005
R430 PAD.n41 PAD.n26 4.5005
R431 PAD.n219 PAD.n26 4.5005
R432 PAD.n42 PAD.n26 4.5005
R433 PAD.n217 PAD.n26 4.5005
R434 PAD.n43 PAD.n26 4.5005
R435 PAD.n215 PAD.n26 4.5005
R436 PAD.n44 PAD.n26 4.5005
R437 PAD.n213 PAD.n26 4.5005
R438 PAD.n45 PAD.n26 4.5005
R439 PAD.n211 PAD.n26 4.5005
R440 PAD.n46 PAD.n26 4.5005
R441 PAD.n209 PAD.n26 4.5005
R442 PAD.n47 PAD.n26 4.5005
R443 PAD.n286 PAD.n26 4.5005
R444 PAD.n288 PAD.n7 4.5005
R445 PAD.n238 PAD.n7 4.5005
R446 PAD.n33 PAD.n7 4.5005
R447 PAD.n236 PAD.n7 4.5005
R448 PAD.n34 PAD.n7 4.5005
R449 PAD.n234 PAD.n7 4.5005
R450 PAD.n35 PAD.n7 4.5005
R451 PAD.n232 PAD.n7 4.5005
R452 PAD.n36 PAD.n7 4.5005
R453 PAD.n230 PAD.n7 4.5005
R454 PAD.n37 PAD.n7 4.5005
R455 PAD.n227 PAD.n7 4.5005
R456 PAD.n38 PAD.n7 4.5005
R457 PAD.n225 PAD.n7 4.5005
R458 PAD.n39 PAD.n7 4.5005
R459 PAD.n223 PAD.n7 4.5005
R460 PAD.n40 PAD.n7 4.5005
R461 PAD.n221 PAD.n7 4.5005
R462 PAD.n41 PAD.n7 4.5005
R463 PAD.n219 PAD.n7 4.5005
R464 PAD.n42 PAD.n7 4.5005
R465 PAD.n217 PAD.n7 4.5005
R466 PAD.n43 PAD.n7 4.5005
R467 PAD.n215 PAD.n7 4.5005
R468 PAD.n44 PAD.n7 4.5005
R469 PAD.n213 PAD.n7 4.5005
R470 PAD.n45 PAD.n7 4.5005
R471 PAD.n211 PAD.n7 4.5005
R472 PAD.n46 PAD.n7 4.5005
R473 PAD.n209 PAD.n7 4.5005
R474 PAD.n47 PAD.n7 4.5005
R475 PAD.n286 PAD.n7 4.5005
R476 PAD.n288 PAD.n25 4.5005
R477 PAD.n238 PAD.n25 4.5005
R478 PAD.n33 PAD.n25 4.5005
R479 PAD.n236 PAD.n25 4.5005
R480 PAD.n34 PAD.n25 4.5005
R481 PAD.n234 PAD.n25 4.5005
R482 PAD.n35 PAD.n25 4.5005
R483 PAD.n232 PAD.n25 4.5005
R484 PAD.n36 PAD.n25 4.5005
R485 PAD.n230 PAD.n25 4.5005
R486 PAD.n37 PAD.n25 4.5005
R487 PAD.n227 PAD.n25 4.5005
R488 PAD.n38 PAD.n25 4.5005
R489 PAD.n225 PAD.n25 4.5005
R490 PAD.n39 PAD.n25 4.5005
R491 PAD.n223 PAD.n25 4.5005
R492 PAD.n40 PAD.n25 4.5005
R493 PAD.n221 PAD.n25 4.5005
R494 PAD.n41 PAD.n25 4.5005
R495 PAD.n219 PAD.n25 4.5005
R496 PAD.n42 PAD.n25 4.5005
R497 PAD.n217 PAD.n25 4.5005
R498 PAD.n43 PAD.n25 4.5005
R499 PAD.n215 PAD.n25 4.5005
R500 PAD.n44 PAD.n25 4.5005
R501 PAD.n213 PAD.n25 4.5005
R502 PAD.n45 PAD.n25 4.5005
R503 PAD.n211 PAD.n25 4.5005
R504 PAD.n46 PAD.n25 4.5005
R505 PAD.n209 PAD.n25 4.5005
R506 PAD.n47 PAD.n25 4.5005
R507 PAD.n286 PAD.n25 4.5005
R508 PAD.n288 PAD.n8 4.5005
R509 PAD.n238 PAD.n8 4.5005
R510 PAD.n33 PAD.n8 4.5005
R511 PAD.n236 PAD.n8 4.5005
R512 PAD.n34 PAD.n8 4.5005
R513 PAD.n234 PAD.n8 4.5005
R514 PAD.n35 PAD.n8 4.5005
R515 PAD.n232 PAD.n8 4.5005
R516 PAD.n36 PAD.n8 4.5005
R517 PAD.n230 PAD.n8 4.5005
R518 PAD.n37 PAD.n8 4.5005
R519 PAD.n227 PAD.n8 4.5005
R520 PAD.n38 PAD.n8 4.5005
R521 PAD.n225 PAD.n8 4.5005
R522 PAD.n39 PAD.n8 4.5005
R523 PAD.n223 PAD.n8 4.5005
R524 PAD.n40 PAD.n8 4.5005
R525 PAD.n221 PAD.n8 4.5005
R526 PAD.n41 PAD.n8 4.5005
R527 PAD.n219 PAD.n8 4.5005
R528 PAD.n42 PAD.n8 4.5005
R529 PAD.n217 PAD.n8 4.5005
R530 PAD.n43 PAD.n8 4.5005
R531 PAD.n215 PAD.n8 4.5005
R532 PAD.n44 PAD.n8 4.5005
R533 PAD.n213 PAD.n8 4.5005
R534 PAD.n45 PAD.n8 4.5005
R535 PAD.n211 PAD.n8 4.5005
R536 PAD.n46 PAD.n8 4.5005
R537 PAD.n209 PAD.n8 4.5005
R538 PAD.n47 PAD.n8 4.5005
R539 PAD.n286 PAD.n8 4.5005
R540 PAD.n288 PAD.n24 4.5005
R541 PAD.n238 PAD.n24 4.5005
R542 PAD.n33 PAD.n24 4.5005
R543 PAD.n236 PAD.n24 4.5005
R544 PAD.n34 PAD.n24 4.5005
R545 PAD.n234 PAD.n24 4.5005
R546 PAD.n35 PAD.n24 4.5005
R547 PAD.n232 PAD.n24 4.5005
R548 PAD.n36 PAD.n24 4.5005
R549 PAD.n230 PAD.n24 4.5005
R550 PAD.n37 PAD.n24 4.5005
R551 PAD.n227 PAD.n24 4.5005
R552 PAD.n38 PAD.n24 4.5005
R553 PAD.n225 PAD.n24 4.5005
R554 PAD.n39 PAD.n24 4.5005
R555 PAD.n223 PAD.n24 4.5005
R556 PAD.n40 PAD.n24 4.5005
R557 PAD.n221 PAD.n24 4.5005
R558 PAD.n41 PAD.n24 4.5005
R559 PAD.n219 PAD.n24 4.5005
R560 PAD.n42 PAD.n24 4.5005
R561 PAD.n217 PAD.n24 4.5005
R562 PAD.n43 PAD.n24 4.5005
R563 PAD.n215 PAD.n24 4.5005
R564 PAD.n44 PAD.n24 4.5005
R565 PAD.n213 PAD.n24 4.5005
R566 PAD.n45 PAD.n24 4.5005
R567 PAD.n211 PAD.n24 4.5005
R568 PAD.n46 PAD.n24 4.5005
R569 PAD.n209 PAD.n24 4.5005
R570 PAD.n47 PAD.n24 4.5005
R571 PAD.n286 PAD.n24 4.5005
R572 PAD.n288 PAD.n9 4.5005
R573 PAD.n238 PAD.n9 4.5005
R574 PAD.n33 PAD.n9 4.5005
R575 PAD.n236 PAD.n9 4.5005
R576 PAD.n34 PAD.n9 4.5005
R577 PAD.n234 PAD.n9 4.5005
R578 PAD.n35 PAD.n9 4.5005
R579 PAD.n232 PAD.n9 4.5005
R580 PAD.n36 PAD.n9 4.5005
R581 PAD.n230 PAD.n9 4.5005
R582 PAD.n37 PAD.n9 4.5005
R583 PAD.n227 PAD.n9 4.5005
R584 PAD.n38 PAD.n9 4.5005
R585 PAD.n225 PAD.n9 4.5005
R586 PAD.n39 PAD.n9 4.5005
R587 PAD.n223 PAD.n9 4.5005
R588 PAD.n40 PAD.n9 4.5005
R589 PAD.n221 PAD.n9 4.5005
R590 PAD.n41 PAD.n9 4.5005
R591 PAD.n219 PAD.n9 4.5005
R592 PAD.n42 PAD.n9 4.5005
R593 PAD.n217 PAD.n9 4.5005
R594 PAD.n43 PAD.n9 4.5005
R595 PAD.n215 PAD.n9 4.5005
R596 PAD.n44 PAD.n9 4.5005
R597 PAD.n213 PAD.n9 4.5005
R598 PAD.n45 PAD.n9 4.5005
R599 PAD.n211 PAD.n9 4.5005
R600 PAD.n46 PAD.n9 4.5005
R601 PAD.n209 PAD.n9 4.5005
R602 PAD.n47 PAD.n9 4.5005
R603 PAD.n286 PAD.n9 4.5005
R604 PAD.n288 PAD.n23 4.5005
R605 PAD.n238 PAD.n23 4.5005
R606 PAD.n33 PAD.n23 4.5005
R607 PAD.n236 PAD.n23 4.5005
R608 PAD.n34 PAD.n23 4.5005
R609 PAD.n234 PAD.n23 4.5005
R610 PAD.n35 PAD.n23 4.5005
R611 PAD.n232 PAD.n23 4.5005
R612 PAD.n36 PAD.n23 4.5005
R613 PAD.n230 PAD.n23 4.5005
R614 PAD.n37 PAD.n23 4.5005
R615 PAD.n227 PAD.n23 4.5005
R616 PAD.n38 PAD.n23 4.5005
R617 PAD.n225 PAD.n23 4.5005
R618 PAD.n39 PAD.n23 4.5005
R619 PAD.n223 PAD.n23 4.5005
R620 PAD.n40 PAD.n23 4.5005
R621 PAD.n221 PAD.n23 4.5005
R622 PAD.n41 PAD.n23 4.5005
R623 PAD.n219 PAD.n23 4.5005
R624 PAD.n42 PAD.n23 4.5005
R625 PAD.n217 PAD.n23 4.5005
R626 PAD.n43 PAD.n23 4.5005
R627 PAD.n215 PAD.n23 4.5005
R628 PAD.n44 PAD.n23 4.5005
R629 PAD.n213 PAD.n23 4.5005
R630 PAD.n45 PAD.n23 4.5005
R631 PAD.n211 PAD.n23 4.5005
R632 PAD.n46 PAD.n23 4.5005
R633 PAD.n209 PAD.n23 4.5005
R634 PAD.n47 PAD.n23 4.5005
R635 PAD.n286 PAD.n23 4.5005
R636 PAD.n288 PAD.n10 4.5005
R637 PAD.n238 PAD.n10 4.5005
R638 PAD.n33 PAD.n10 4.5005
R639 PAD.n236 PAD.n10 4.5005
R640 PAD.n34 PAD.n10 4.5005
R641 PAD.n234 PAD.n10 4.5005
R642 PAD.n35 PAD.n10 4.5005
R643 PAD.n232 PAD.n10 4.5005
R644 PAD.n36 PAD.n10 4.5005
R645 PAD.n230 PAD.n10 4.5005
R646 PAD.n37 PAD.n10 4.5005
R647 PAD.n227 PAD.n10 4.5005
R648 PAD.n38 PAD.n10 4.5005
R649 PAD.n225 PAD.n10 4.5005
R650 PAD.n39 PAD.n10 4.5005
R651 PAD.n223 PAD.n10 4.5005
R652 PAD.n40 PAD.n10 4.5005
R653 PAD.n221 PAD.n10 4.5005
R654 PAD.n41 PAD.n10 4.5005
R655 PAD.n219 PAD.n10 4.5005
R656 PAD.n42 PAD.n10 4.5005
R657 PAD.n217 PAD.n10 4.5005
R658 PAD.n43 PAD.n10 4.5005
R659 PAD.n215 PAD.n10 4.5005
R660 PAD.n44 PAD.n10 4.5005
R661 PAD.n213 PAD.n10 4.5005
R662 PAD.n45 PAD.n10 4.5005
R663 PAD.n211 PAD.n10 4.5005
R664 PAD.n46 PAD.n10 4.5005
R665 PAD.n209 PAD.n10 4.5005
R666 PAD.n47 PAD.n10 4.5005
R667 PAD.n286 PAD.n10 4.5005
R668 PAD.n288 PAD.n22 4.5005
R669 PAD.n238 PAD.n22 4.5005
R670 PAD.n33 PAD.n22 4.5005
R671 PAD.n236 PAD.n22 4.5005
R672 PAD.n34 PAD.n22 4.5005
R673 PAD.n234 PAD.n22 4.5005
R674 PAD.n35 PAD.n22 4.5005
R675 PAD.n232 PAD.n22 4.5005
R676 PAD.n36 PAD.n22 4.5005
R677 PAD.n230 PAD.n22 4.5005
R678 PAD.n37 PAD.n22 4.5005
R679 PAD.n227 PAD.n22 4.5005
R680 PAD.n38 PAD.n22 4.5005
R681 PAD.n225 PAD.n22 4.5005
R682 PAD.n39 PAD.n22 4.5005
R683 PAD.n223 PAD.n22 4.5005
R684 PAD.n40 PAD.n22 4.5005
R685 PAD.n221 PAD.n22 4.5005
R686 PAD.n41 PAD.n22 4.5005
R687 PAD.n219 PAD.n22 4.5005
R688 PAD.n42 PAD.n22 4.5005
R689 PAD.n217 PAD.n22 4.5005
R690 PAD.n43 PAD.n22 4.5005
R691 PAD.n215 PAD.n22 4.5005
R692 PAD.n44 PAD.n22 4.5005
R693 PAD.n213 PAD.n22 4.5005
R694 PAD.n45 PAD.n22 4.5005
R695 PAD.n211 PAD.n22 4.5005
R696 PAD.n46 PAD.n22 4.5005
R697 PAD.n209 PAD.n22 4.5005
R698 PAD.n47 PAD.n22 4.5005
R699 PAD.n286 PAD.n22 4.5005
R700 PAD.n288 PAD.n11 4.5005
R701 PAD.n238 PAD.n11 4.5005
R702 PAD.n33 PAD.n11 4.5005
R703 PAD.n236 PAD.n11 4.5005
R704 PAD.n34 PAD.n11 4.5005
R705 PAD.n234 PAD.n11 4.5005
R706 PAD.n35 PAD.n11 4.5005
R707 PAD.n232 PAD.n11 4.5005
R708 PAD.n36 PAD.n11 4.5005
R709 PAD.n230 PAD.n11 4.5005
R710 PAD.n37 PAD.n11 4.5005
R711 PAD.n227 PAD.n11 4.5005
R712 PAD.n38 PAD.n11 4.5005
R713 PAD.n225 PAD.n11 4.5005
R714 PAD.n39 PAD.n11 4.5005
R715 PAD.n223 PAD.n11 4.5005
R716 PAD.n40 PAD.n11 4.5005
R717 PAD.n221 PAD.n11 4.5005
R718 PAD.n41 PAD.n11 4.5005
R719 PAD.n219 PAD.n11 4.5005
R720 PAD.n42 PAD.n11 4.5005
R721 PAD.n217 PAD.n11 4.5005
R722 PAD.n43 PAD.n11 4.5005
R723 PAD.n215 PAD.n11 4.5005
R724 PAD.n44 PAD.n11 4.5005
R725 PAD.n213 PAD.n11 4.5005
R726 PAD.n45 PAD.n11 4.5005
R727 PAD.n211 PAD.n11 4.5005
R728 PAD.n46 PAD.n11 4.5005
R729 PAD.n209 PAD.n11 4.5005
R730 PAD.n47 PAD.n11 4.5005
R731 PAD.n286 PAD.n11 4.5005
R732 PAD.n288 PAD.n21 4.5005
R733 PAD.n238 PAD.n21 4.5005
R734 PAD.n33 PAD.n21 4.5005
R735 PAD.n236 PAD.n21 4.5005
R736 PAD.n34 PAD.n21 4.5005
R737 PAD.n234 PAD.n21 4.5005
R738 PAD.n35 PAD.n21 4.5005
R739 PAD.n232 PAD.n21 4.5005
R740 PAD.n36 PAD.n21 4.5005
R741 PAD.n230 PAD.n21 4.5005
R742 PAD.n37 PAD.n21 4.5005
R743 PAD.n227 PAD.n21 4.5005
R744 PAD.n38 PAD.n21 4.5005
R745 PAD.n225 PAD.n21 4.5005
R746 PAD.n39 PAD.n21 4.5005
R747 PAD.n223 PAD.n21 4.5005
R748 PAD.n40 PAD.n21 4.5005
R749 PAD.n221 PAD.n21 4.5005
R750 PAD.n41 PAD.n21 4.5005
R751 PAD.n219 PAD.n21 4.5005
R752 PAD.n42 PAD.n21 4.5005
R753 PAD.n217 PAD.n21 4.5005
R754 PAD.n43 PAD.n21 4.5005
R755 PAD.n215 PAD.n21 4.5005
R756 PAD.n44 PAD.n21 4.5005
R757 PAD.n213 PAD.n21 4.5005
R758 PAD.n45 PAD.n21 4.5005
R759 PAD.n211 PAD.n21 4.5005
R760 PAD.n46 PAD.n21 4.5005
R761 PAD.n209 PAD.n21 4.5005
R762 PAD.n47 PAD.n21 4.5005
R763 PAD.n286 PAD.n21 4.5005
R764 PAD.n288 PAD.n12 4.5005
R765 PAD.n238 PAD.n12 4.5005
R766 PAD.n33 PAD.n12 4.5005
R767 PAD.n236 PAD.n12 4.5005
R768 PAD.n34 PAD.n12 4.5005
R769 PAD.n234 PAD.n12 4.5005
R770 PAD.n35 PAD.n12 4.5005
R771 PAD.n232 PAD.n12 4.5005
R772 PAD.n36 PAD.n12 4.5005
R773 PAD.n230 PAD.n12 4.5005
R774 PAD.n37 PAD.n12 4.5005
R775 PAD.n227 PAD.n12 4.5005
R776 PAD.n38 PAD.n12 4.5005
R777 PAD.n225 PAD.n12 4.5005
R778 PAD.n39 PAD.n12 4.5005
R779 PAD.n223 PAD.n12 4.5005
R780 PAD.n40 PAD.n12 4.5005
R781 PAD.n221 PAD.n12 4.5005
R782 PAD.n41 PAD.n12 4.5005
R783 PAD.n219 PAD.n12 4.5005
R784 PAD.n42 PAD.n12 4.5005
R785 PAD.n217 PAD.n12 4.5005
R786 PAD.n43 PAD.n12 4.5005
R787 PAD.n215 PAD.n12 4.5005
R788 PAD.n44 PAD.n12 4.5005
R789 PAD.n213 PAD.n12 4.5005
R790 PAD.n45 PAD.n12 4.5005
R791 PAD.n211 PAD.n12 4.5005
R792 PAD.n46 PAD.n12 4.5005
R793 PAD.n209 PAD.n12 4.5005
R794 PAD.n47 PAD.n12 4.5005
R795 PAD.n286 PAD.n12 4.5005
R796 PAD.n288 PAD.n20 4.5005
R797 PAD.n238 PAD.n20 4.5005
R798 PAD.n33 PAD.n20 4.5005
R799 PAD.n236 PAD.n20 4.5005
R800 PAD.n34 PAD.n20 4.5005
R801 PAD.n234 PAD.n20 4.5005
R802 PAD.n35 PAD.n20 4.5005
R803 PAD.n232 PAD.n20 4.5005
R804 PAD.n36 PAD.n20 4.5005
R805 PAD.n230 PAD.n20 4.5005
R806 PAD.n37 PAD.n20 4.5005
R807 PAD.n227 PAD.n20 4.5005
R808 PAD.n38 PAD.n20 4.5005
R809 PAD.n225 PAD.n20 4.5005
R810 PAD.n39 PAD.n20 4.5005
R811 PAD.n223 PAD.n20 4.5005
R812 PAD.n40 PAD.n20 4.5005
R813 PAD.n221 PAD.n20 4.5005
R814 PAD.n41 PAD.n20 4.5005
R815 PAD.n219 PAD.n20 4.5005
R816 PAD.n42 PAD.n20 4.5005
R817 PAD.n217 PAD.n20 4.5005
R818 PAD.n43 PAD.n20 4.5005
R819 PAD.n215 PAD.n20 4.5005
R820 PAD.n44 PAD.n20 4.5005
R821 PAD.n213 PAD.n20 4.5005
R822 PAD.n45 PAD.n20 4.5005
R823 PAD.n211 PAD.n20 4.5005
R824 PAD.n46 PAD.n20 4.5005
R825 PAD.n209 PAD.n20 4.5005
R826 PAD.n47 PAD.n20 4.5005
R827 PAD.n286 PAD.n20 4.5005
R828 PAD.n288 PAD.n13 4.5005
R829 PAD.n238 PAD.n13 4.5005
R830 PAD.n33 PAD.n13 4.5005
R831 PAD.n236 PAD.n13 4.5005
R832 PAD.n34 PAD.n13 4.5005
R833 PAD.n234 PAD.n13 4.5005
R834 PAD.n35 PAD.n13 4.5005
R835 PAD.n232 PAD.n13 4.5005
R836 PAD.n36 PAD.n13 4.5005
R837 PAD.n230 PAD.n13 4.5005
R838 PAD.n37 PAD.n13 4.5005
R839 PAD.n227 PAD.n13 4.5005
R840 PAD.n38 PAD.n13 4.5005
R841 PAD.n225 PAD.n13 4.5005
R842 PAD.n39 PAD.n13 4.5005
R843 PAD.n223 PAD.n13 4.5005
R844 PAD.n40 PAD.n13 4.5005
R845 PAD.n221 PAD.n13 4.5005
R846 PAD.n41 PAD.n13 4.5005
R847 PAD.n219 PAD.n13 4.5005
R848 PAD.n42 PAD.n13 4.5005
R849 PAD.n217 PAD.n13 4.5005
R850 PAD.n43 PAD.n13 4.5005
R851 PAD.n215 PAD.n13 4.5005
R852 PAD.n44 PAD.n13 4.5005
R853 PAD.n213 PAD.n13 4.5005
R854 PAD.n45 PAD.n13 4.5005
R855 PAD.n211 PAD.n13 4.5005
R856 PAD.n46 PAD.n13 4.5005
R857 PAD.n209 PAD.n13 4.5005
R858 PAD.n47 PAD.n13 4.5005
R859 PAD.n286 PAD.n13 4.5005
R860 PAD.n288 PAD.n19 4.5005
R861 PAD.n238 PAD.n19 4.5005
R862 PAD.n33 PAD.n19 4.5005
R863 PAD.n236 PAD.n19 4.5005
R864 PAD.n34 PAD.n19 4.5005
R865 PAD.n234 PAD.n19 4.5005
R866 PAD.n35 PAD.n19 4.5005
R867 PAD.n232 PAD.n19 4.5005
R868 PAD.n36 PAD.n19 4.5005
R869 PAD.n230 PAD.n19 4.5005
R870 PAD.n37 PAD.n19 4.5005
R871 PAD.n227 PAD.n19 4.5005
R872 PAD.n38 PAD.n19 4.5005
R873 PAD.n225 PAD.n19 4.5005
R874 PAD.n39 PAD.n19 4.5005
R875 PAD.n223 PAD.n19 4.5005
R876 PAD.n40 PAD.n19 4.5005
R877 PAD.n221 PAD.n19 4.5005
R878 PAD.n41 PAD.n19 4.5005
R879 PAD.n219 PAD.n19 4.5005
R880 PAD.n42 PAD.n19 4.5005
R881 PAD.n217 PAD.n19 4.5005
R882 PAD.n43 PAD.n19 4.5005
R883 PAD.n215 PAD.n19 4.5005
R884 PAD.n44 PAD.n19 4.5005
R885 PAD.n213 PAD.n19 4.5005
R886 PAD.n45 PAD.n19 4.5005
R887 PAD.n211 PAD.n19 4.5005
R888 PAD.n46 PAD.n19 4.5005
R889 PAD.n209 PAD.n19 4.5005
R890 PAD.n47 PAD.n19 4.5005
R891 PAD.n286 PAD.n19 4.5005
R892 PAD.n288 PAD.n14 4.5005
R893 PAD.n238 PAD.n14 4.5005
R894 PAD.n33 PAD.n14 4.5005
R895 PAD.n236 PAD.n14 4.5005
R896 PAD.n34 PAD.n14 4.5005
R897 PAD.n234 PAD.n14 4.5005
R898 PAD.n35 PAD.n14 4.5005
R899 PAD.n232 PAD.n14 4.5005
R900 PAD.n36 PAD.n14 4.5005
R901 PAD.n230 PAD.n14 4.5005
R902 PAD.n37 PAD.n14 4.5005
R903 PAD.n227 PAD.n14 4.5005
R904 PAD.n38 PAD.n14 4.5005
R905 PAD.n225 PAD.n14 4.5005
R906 PAD.n39 PAD.n14 4.5005
R907 PAD.n223 PAD.n14 4.5005
R908 PAD.n40 PAD.n14 4.5005
R909 PAD.n221 PAD.n14 4.5005
R910 PAD.n41 PAD.n14 4.5005
R911 PAD.n219 PAD.n14 4.5005
R912 PAD.n42 PAD.n14 4.5005
R913 PAD.n217 PAD.n14 4.5005
R914 PAD.n43 PAD.n14 4.5005
R915 PAD.n215 PAD.n14 4.5005
R916 PAD.n44 PAD.n14 4.5005
R917 PAD.n213 PAD.n14 4.5005
R918 PAD.n45 PAD.n14 4.5005
R919 PAD.n211 PAD.n14 4.5005
R920 PAD.n46 PAD.n14 4.5005
R921 PAD.n209 PAD.n14 4.5005
R922 PAD.n47 PAD.n14 4.5005
R923 PAD.n286 PAD.n14 4.5005
R924 PAD.n288 PAD.n18 4.5005
R925 PAD.n238 PAD.n18 4.5005
R926 PAD.n33 PAD.n18 4.5005
R927 PAD.n236 PAD.n18 4.5005
R928 PAD.n34 PAD.n18 4.5005
R929 PAD.n234 PAD.n18 4.5005
R930 PAD.n35 PAD.n18 4.5005
R931 PAD.n232 PAD.n18 4.5005
R932 PAD.n36 PAD.n18 4.5005
R933 PAD.n230 PAD.n18 4.5005
R934 PAD.n37 PAD.n18 4.5005
R935 PAD.n227 PAD.n18 4.5005
R936 PAD.n38 PAD.n18 4.5005
R937 PAD.n225 PAD.n18 4.5005
R938 PAD.n39 PAD.n18 4.5005
R939 PAD.n223 PAD.n18 4.5005
R940 PAD.n40 PAD.n18 4.5005
R941 PAD.n221 PAD.n18 4.5005
R942 PAD.n41 PAD.n18 4.5005
R943 PAD.n219 PAD.n18 4.5005
R944 PAD.n42 PAD.n18 4.5005
R945 PAD.n217 PAD.n18 4.5005
R946 PAD.n43 PAD.n18 4.5005
R947 PAD.n215 PAD.n18 4.5005
R948 PAD.n44 PAD.n18 4.5005
R949 PAD.n213 PAD.n18 4.5005
R950 PAD.n45 PAD.n18 4.5005
R951 PAD.n211 PAD.n18 4.5005
R952 PAD.n46 PAD.n18 4.5005
R953 PAD.n209 PAD.n18 4.5005
R954 PAD.n47 PAD.n18 4.5005
R955 PAD.n286 PAD.n18 4.5005
R956 PAD.n288 PAD.n15 4.5005
R957 PAD.n238 PAD.n15 4.5005
R958 PAD.n33 PAD.n15 4.5005
R959 PAD.n236 PAD.n15 4.5005
R960 PAD.n34 PAD.n15 4.5005
R961 PAD.n234 PAD.n15 4.5005
R962 PAD.n35 PAD.n15 4.5005
R963 PAD.n232 PAD.n15 4.5005
R964 PAD.n37 PAD.n15 4.5005
R965 PAD.n227 PAD.n15 4.5005
R966 PAD.n38 PAD.n15 4.5005
R967 PAD.n225 PAD.n15 4.5005
R968 PAD.n40 PAD.n15 4.5005
R969 PAD.n221 PAD.n15 4.5005
R970 PAD.n41 PAD.n15 4.5005
R971 PAD.n219 PAD.n15 4.5005
R972 PAD.n42 PAD.n15 4.5005
R973 PAD.n217 PAD.n15 4.5005
R974 PAD.n43 PAD.n15 4.5005
R975 PAD.n215 PAD.n15 4.5005
R976 PAD.n44 PAD.n15 4.5005
R977 PAD.n213 PAD.n15 4.5005
R978 PAD.n45 PAD.n15 4.5005
R979 PAD.n211 PAD.n15 4.5005
R980 PAD.n46 PAD.n15 4.5005
R981 PAD.n209 PAD.n15 4.5005
R982 PAD.n47 PAD.n15 4.5005
R983 PAD.n286 PAD.n15 4.5005
R984 PAD.n254 PAD.n35 4.5005
R985 PAD.n254 PAD.n230 4.5005
R986 PAD.n254 PAD.n39 4.5005
R987 PAD.n286 PAD.n254 4.5005
R988 PAD.n288 PAD.n16 4.5005
R989 PAD.n234 PAD.n16 4.5005
R990 PAD.n36 PAD.n16 4.5005
R991 PAD.n223 PAD.n16 4.5005
R992 PAD.n233 PAD.n32 4.5005
R993 PAD.n287 PAD.n207 4.5005
R994 PAD.n287 PAD.n49 4.5005
R995 PAD.n287 PAD.n163 4.5005
R996 PAD.n287 PAD.n50 4.5005
R997 PAD.n287 PAD.n161 4.5005
R998 PAD.n287 PAD.n51 4.5005
R999 PAD.n287 PAD.n158 4.5005
R1000 PAD.n287 PAD.n52 4.5005
R1001 PAD.n287 PAD.n155 4.5005
R1002 PAD.n287 PAD.n53 4.5005
R1003 PAD.n287 PAD.n152 4.5005
R1004 PAD.n287 PAD.n54 4.5005
R1005 PAD.n287 PAD.n149 4.5005
R1006 PAD.n287 PAD.n55 4.5005
R1007 PAD.n287 PAD.n146 4.5005
R1008 PAD.n287 PAD.n56 4.5005
R1009 PAD.n287 PAD.n143 4.5005
R1010 PAD.n287 PAD.n57 4.5005
R1011 PAD.n287 PAD.n140 4.5005
R1012 PAD.n287 PAD.n58 4.5005
R1013 PAD.n287 PAD.n137 4.5005
R1014 PAD.n287 PAD.n59 4.5005
R1015 PAD.n287 PAD.n134 4.5005
R1016 PAD.n287 PAD.n60 4.5005
R1017 PAD.n287 PAD.n131 4.5005
R1018 PAD.n287 PAD.n61 4.5005
R1019 PAD.n287 PAD.n128 4.5005
R1020 PAD.n287 PAD.n62 4.5005
R1021 PAD.n287 PAD.n125 4.5005
R1022 PAD.n287 PAD.n63 4.5005
R1023 PAD.n287 PAD.n122 4.5005
R1024 PAD.n287 PAD.n77 4.5005
R1025 PAD.n49 PAD.n1 4.5005
R1026 PAD.n163 PAD.n1 4.5005
R1027 PAD.n50 PAD.n1 4.5005
R1028 PAD.n161 PAD.n1 4.5005
R1029 PAD.n51 PAD.n1 4.5005
R1030 PAD.n158 PAD.n1 4.5005
R1031 PAD.n52 PAD.n1 4.5005
R1032 PAD.n155 PAD.n1 4.5005
R1033 PAD.n53 PAD.n1 4.5005
R1034 PAD.n152 PAD.n1 4.5005
R1035 PAD.n54 PAD.n1 4.5005
R1036 PAD.n149 PAD.n1 4.5005
R1037 PAD.n55 PAD.n1 4.5005
R1038 PAD.n146 PAD.n1 4.5005
R1039 PAD.n56 PAD.n1 4.5005
R1040 PAD.n143 PAD.n1 4.5005
R1041 PAD.n57 PAD.n1 4.5005
R1042 PAD.n140 PAD.n1 4.5005
R1043 PAD.n58 PAD.n1 4.5005
R1044 PAD.n137 PAD.n1 4.5005
R1045 PAD.n59 PAD.n1 4.5005
R1046 PAD.n134 PAD.n1 4.5005
R1047 PAD.n60 PAD.n1 4.5005
R1048 PAD.n131 PAD.n1 4.5005
R1049 PAD.n61 PAD.n1 4.5005
R1050 PAD.n128 PAD.n1 4.5005
R1051 PAD.n62 PAD.n1 4.5005
R1052 PAD.n125 PAD.n1 4.5005
R1053 PAD.n63 PAD.n1 4.5005
R1054 PAD.n122 PAD.n1 4.5005
R1055 PAD.n207 PAD.n1 4.5005
R1056 PAD.n49 PAD.n31 4.5005
R1057 PAD.n163 PAD.n31 4.5005
R1058 PAD.n50 PAD.n31 4.5005
R1059 PAD.n161 PAD.n31 4.5005
R1060 PAD.n51 PAD.n31 4.5005
R1061 PAD.n158 PAD.n31 4.5005
R1062 PAD.n52 PAD.n31 4.5005
R1063 PAD.n155 PAD.n31 4.5005
R1064 PAD.n53 PAD.n31 4.5005
R1065 PAD.n152 PAD.n31 4.5005
R1066 PAD.n54 PAD.n31 4.5005
R1067 PAD.n149 PAD.n31 4.5005
R1068 PAD.n55 PAD.n31 4.5005
R1069 PAD.n146 PAD.n31 4.5005
R1070 PAD.n56 PAD.n31 4.5005
R1071 PAD.n143 PAD.n31 4.5005
R1072 PAD.n57 PAD.n31 4.5005
R1073 PAD.n140 PAD.n31 4.5005
R1074 PAD.n58 PAD.n31 4.5005
R1075 PAD.n137 PAD.n31 4.5005
R1076 PAD.n59 PAD.n31 4.5005
R1077 PAD.n134 PAD.n31 4.5005
R1078 PAD.n60 PAD.n31 4.5005
R1079 PAD.n131 PAD.n31 4.5005
R1080 PAD.n61 PAD.n31 4.5005
R1081 PAD.n128 PAD.n31 4.5005
R1082 PAD.n62 PAD.n31 4.5005
R1083 PAD.n125 PAD.n31 4.5005
R1084 PAD.n63 PAD.n31 4.5005
R1085 PAD.n122 PAD.n31 4.5005
R1086 PAD.n49 PAD.n2 4.5005
R1087 PAD.n163 PAD.n2 4.5005
R1088 PAD.n50 PAD.n2 4.5005
R1089 PAD.n161 PAD.n2 4.5005
R1090 PAD.n51 PAD.n2 4.5005
R1091 PAD.n158 PAD.n2 4.5005
R1092 PAD.n52 PAD.n2 4.5005
R1093 PAD.n155 PAD.n2 4.5005
R1094 PAD.n53 PAD.n2 4.5005
R1095 PAD.n152 PAD.n2 4.5005
R1096 PAD.n54 PAD.n2 4.5005
R1097 PAD.n149 PAD.n2 4.5005
R1098 PAD.n55 PAD.n2 4.5005
R1099 PAD.n146 PAD.n2 4.5005
R1100 PAD.n56 PAD.n2 4.5005
R1101 PAD.n143 PAD.n2 4.5005
R1102 PAD.n57 PAD.n2 4.5005
R1103 PAD.n140 PAD.n2 4.5005
R1104 PAD.n58 PAD.n2 4.5005
R1105 PAD.n137 PAD.n2 4.5005
R1106 PAD.n59 PAD.n2 4.5005
R1107 PAD.n134 PAD.n2 4.5005
R1108 PAD.n60 PAD.n2 4.5005
R1109 PAD.n131 PAD.n2 4.5005
R1110 PAD.n61 PAD.n2 4.5005
R1111 PAD.n128 PAD.n2 4.5005
R1112 PAD.n62 PAD.n2 4.5005
R1113 PAD.n125 PAD.n2 4.5005
R1114 PAD.n63 PAD.n2 4.5005
R1115 PAD.n122 PAD.n2 4.5005
R1116 PAD.n49 PAD.n30 4.5005
R1117 PAD.n163 PAD.n30 4.5005
R1118 PAD.n50 PAD.n30 4.5005
R1119 PAD.n161 PAD.n30 4.5005
R1120 PAD.n51 PAD.n30 4.5005
R1121 PAD.n158 PAD.n30 4.5005
R1122 PAD.n52 PAD.n30 4.5005
R1123 PAD.n155 PAD.n30 4.5005
R1124 PAD.n53 PAD.n30 4.5005
R1125 PAD.n152 PAD.n30 4.5005
R1126 PAD.n54 PAD.n30 4.5005
R1127 PAD.n149 PAD.n30 4.5005
R1128 PAD.n55 PAD.n30 4.5005
R1129 PAD.n146 PAD.n30 4.5005
R1130 PAD.n56 PAD.n30 4.5005
R1131 PAD.n143 PAD.n30 4.5005
R1132 PAD.n57 PAD.n30 4.5005
R1133 PAD.n140 PAD.n30 4.5005
R1134 PAD.n58 PAD.n30 4.5005
R1135 PAD.n137 PAD.n30 4.5005
R1136 PAD.n59 PAD.n30 4.5005
R1137 PAD.n134 PAD.n30 4.5005
R1138 PAD.n60 PAD.n30 4.5005
R1139 PAD.n131 PAD.n30 4.5005
R1140 PAD.n61 PAD.n30 4.5005
R1141 PAD.n128 PAD.n30 4.5005
R1142 PAD.n62 PAD.n30 4.5005
R1143 PAD.n125 PAD.n30 4.5005
R1144 PAD.n63 PAD.n30 4.5005
R1145 PAD.n122 PAD.n30 4.5005
R1146 PAD.n49 PAD.n3 4.5005
R1147 PAD.n163 PAD.n3 4.5005
R1148 PAD.n50 PAD.n3 4.5005
R1149 PAD.n161 PAD.n3 4.5005
R1150 PAD.n51 PAD.n3 4.5005
R1151 PAD.n158 PAD.n3 4.5005
R1152 PAD.n52 PAD.n3 4.5005
R1153 PAD.n155 PAD.n3 4.5005
R1154 PAD.n53 PAD.n3 4.5005
R1155 PAD.n152 PAD.n3 4.5005
R1156 PAD.n54 PAD.n3 4.5005
R1157 PAD.n149 PAD.n3 4.5005
R1158 PAD.n55 PAD.n3 4.5005
R1159 PAD.n146 PAD.n3 4.5005
R1160 PAD.n56 PAD.n3 4.5005
R1161 PAD.n143 PAD.n3 4.5005
R1162 PAD.n57 PAD.n3 4.5005
R1163 PAD.n140 PAD.n3 4.5005
R1164 PAD.n58 PAD.n3 4.5005
R1165 PAD.n137 PAD.n3 4.5005
R1166 PAD.n59 PAD.n3 4.5005
R1167 PAD.n134 PAD.n3 4.5005
R1168 PAD.n60 PAD.n3 4.5005
R1169 PAD.n131 PAD.n3 4.5005
R1170 PAD.n61 PAD.n3 4.5005
R1171 PAD.n128 PAD.n3 4.5005
R1172 PAD.n62 PAD.n3 4.5005
R1173 PAD.n125 PAD.n3 4.5005
R1174 PAD.n63 PAD.n3 4.5005
R1175 PAD.n77 PAD.n3 4.5005
R1176 PAD.n49 PAD.n29 4.5005
R1177 PAD.n163 PAD.n29 4.5005
R1178 PAD.n50 PAD.n29 4.5005
R1179 PAD.n161 PAD.n29 4.5005
R1180 PAD.n51 PAD.n29 4.5005
R1181 PAD.n158 PAD.n29 4.5005
R1182 PAD.n52 PAD.n29 4.5005
R1183 PAD.n155 PAD.n29 4.5005
R1184 PAD.n53 PAD.n29 4.5005
R1185 PAD.n152 PAD.n29 4.5005
R1186 PAD.n54 PAD.n29 4.5005
R1187 PAD.n149 PAD.n29 4.5005
R1188 PAD.n55 PAD.n29 4.5005
R1189 PAD.n146 PAD.n29 4.5005
R1190 PAD.n56 PAD.n29 4.5005
R1191 PAD.n143 PAD.n29 4.5005
R1192 PAD.n57 PAD.n29 4.5005
R1193 PAD.n140 PAD.n29 4.5005
R1194 PAD.n58 PAD.n29 4.5005
R1195 PAD.n137 PAD.n29 4.5005
R1196 PAD.n59 PAD.n29 4.5005
R1197 PAD.n134 PAD.n29 4.5005
R1198 PAD.n60 PAD.n29 4.5005
R1199 PAD.n131 PAD.n29 4.5005
R1200 PAD.n61 PAD.n29 4.5005
R1201 PAD.n128 PAD.n29 4.5005
R1202 PAD.n62 PAD.n29 4.5005
R1203 PAD.n125 PAD.n29 4.5005
R1204 PAD.n63 PAD.n29 4.5005
R1205 PAD.n207 PAD.n29 4.5005
R1206 PAD.n49 PAD.n4 4.5005
R1207 PAD.n163 PAD.n4 4.5005
R1208 PAD.n50 PAD.n4 4.5005
R1209 PAD.n161 PAD.n4 4.5005
R1210 PAD.n51 PAD.n4 4.5005
R1211 PAD.n158 PAD.n4 4.5005
R1212 PAD.n52 PAD.n4 4.5005
R1213 PAD.n155 PAD.n4 4.5005
R1214 PAD.n53 PAD.n4 4.5005
R1215 PAD.n152 PAD.n4 4.5005
R1216 PAD.n54 PAD.n4 4.5005
R1217 PAD.n149 PAD.n4 4.5005
R1218 PAD.n55 PAD.n4 4.5005
R1219 PAD.n146 PAD.n4 4.5005
R1220 PAD.n56 PAD.n4 4.5005
R1221 PAD.n143 PAD.n4 4.5005
R1222 PAD.n57 PAD.n4 4.5005
R1223 PAD.n140 PAD.n4 4.5005
R1224 PAD.n58 PAD.n4 4.5005
R1225 PAD.n137 PAD.n4 4.5005
R1226 PAD.n59 PAD.n4 4.5005
R1227 PAD.n134 PAD.n4 4.5005
R1228 PAD.n60 PAD.n4 4.5005
R1229 PAD.n131 PAD.n4 4.5005
R1230 PAD.n61 PAD.n4 4.5005
R1231 PAD.n128 PAD.n4 4.5005
R1232 PAD.n62 PAD.n4 4.5005
R1233 PAD.n125 PAD.n4 4.5005
R1234 PAD.n63 PAD.n4 4.5005
R1235 PAD.n122 PAD.n4 4.5005
R1236 PAD.n49 PAD.n28 4.5005
R1237 PAD.n163 PAD.n28 4.5005
R1238 PAD.n50 PAD.n28 4.5005
R1239 PAD.n161 PAD.n28 4.5005
R1240 PAD.n51 PAD.n28 4.5005
R1241 PAD.n158 PAD.n28 4.5005
R1242 PAD.n52 PAD.n28 4.5005
R1243 PAD.n155 PAD.n28 4.5005
R1244 PAD.n53 PAD.n28 4.5005
R1245 PAD.n152 PAD.n28 4.5005
R1246 PAD.n54 PAD.n28 4.5005
R1247 PAD.n149 PAD.n28 4.5005
R1248 PAD.n55 PAD.n28 4.5005
R1249 PAD.n146 PAD.n28 4.5005
R1250 PAD.n56 PAD.n28 4.5005
R1251 PAD.n143 PAD.n28 4.5005
R1252 PAD.n57 PAD.n28 4.5005
R1253 PAD.n140 PAD.n28 4.5005
R1254 PAD.n58 PAD.n28 4.5005
R1255 PAD.n137 PAD.n28 4.5005
R1256 PAD.n59 PAD.n28 4.5005
R1257 PAD.n134 PAD.n28 4.5005
R1258 PAD.n60 PAD.n28 4.5005
R1259 PAD.n131 PAD.n28 4.5005
R1260 PAD.n61 PAD.n28 4.5005
R1261 PAD.n128 PAD.n28 4.5005
R1262 PAD.n62 PAD.n28 4.5005
R1263 PAD.n125 PAD.n28 4.5005
R1264 PAD.n63 PAD.n28 4.5005
R1265 PAD.n122 PAD.n28 4.5005
R1266 PAD.n49 PAD.n5 4.5005
R1267 PAD.n163 PAD.n5 4.5005
R1268 PAD.n50 PAD.n5 4.5005
R1269 PAD.n161 PAD.n5 4.5005
R1270 PAD.n51 PAD.n5 4.5005
R1271 PAD.n158 PAD.n5 4.5005
R1272 PAD.n52 PAD.n5 4.5005
R1273 PAD.n155 PAD.n5 4.5005
R1274 PAD.n53 PAD.n5 4.5005
R1275 PAD.n152 PAD.n5 4.5005
R1276 PAD.n54 PAD.n5 4.5005
R1277 PAD.n149 PAD.n5 4.5005
R1278 PAD.n55 PAD.n5 4.5005
R1279 PAD.n146 PAD.n5 4.5005
R1280 PAD.n56 PAD.n5 4.5005
R1281 PAD.n143 PAD.n5 4.5005
R1282 PAD.n57 PAD.n5 4.5005
R1283 PAD.n140 PAD.n5 4.5005
R1284 PAD.n58 PAD.n5 4.5005
R1285 PAD.n137 PAD.n5 4.5005
R1286 PAD.n59 PAD.n5 4.5005
R1287 PAD.n134 PAD.n5 4.5005
R1288 PAD.n60 PAD.n5 4.5005
R1289 PAD.n131 PAD.n5 4.5005
R1290 PAD.n61 PAD.n5 4.5005
R1291 PAD.n128 PAD.n5 4.5005
R1292 PAD.n62 PAD.n5 4.5005
R1293 PAD.n125 PAD.n5 4.5005
R1294 PAD.n63 PAD.n5 4.5005
R1295 PAD.n122 PAD.n5 4.5005
R1296 PAD.n49 PAD.n27 4.5005
R1297 PAD.n163 PAD.n27 4.5005
R1298 PAD.n50 PAD.n27 4.5005
R1299 PAD.n161 PAD.n27 4.5005
R1300 PAD.n51 PAD.n27 4.5005
R1301 PAD.n158 PAD.n27 4.5005
R1302 PAD.n52 PAD.n27 4.5005
R1303 PAD.n155 PAD.n27 4.5005
R1304 PAD.n53 PAD.n27 4.5005
R1305 PAD.n152 PAD.n27 4.5005
R1306 PAD.n54 PAD.n27 4.5005
R1307 PAD.n149 PAD.n27 4.5005
R1308 PAD.n55 PAD.n27 4.5005
R1309 PAD.n146 PAD.n27 4.5005
R1310 PAD.n56 PAD.n27 4.5005
R1311 PAD.n143 PAD.n27 4.5005
R1312 PAD.n57 PAD.n27 4.5005
R1313 PAD.n140 PAD.n27 4.5005
R1314 PAD.n58 PAD.n27 4.5005
R1315 PAD.n137 PAD.n27 4.5005
R1316 PAD.n59 PAD.n27 4.5005
R1317 PAD.n134 PAD.n27 4.5005
R1318 PAD.n60 PAD.n27 4.5005
R1319 PAD.n131 PAD.n27 4.5005
R1320 PAD.n61 PAD.n27 4.5005
R1321 PAD.n128 PAD.n27 4.5005
R1322 PAD.n62 PAD.n27 4.5005
R1323 PAD.n125 PAD.n27 4.5005
R1324 PAD.n63 PAD.n27 4.5005
R1325 PAD.n122 PAD.n27 4.5005
R1326 PAD.n49 PAD.n6 4.5005
R1327 PAD.n163 PAD.n6 4.5005
R1328 PAD.n50 PAD.n6 4.5005
R1329 PAD.n161 PAD.n6 4.5005
R1330 PAD.n51 PAD.n6 4.5005
R1331 PAD.n158 PAD.n6 4.5005
R1332 PAD.n52 PAD.n6 4.5005
R1333 PAD.n155 PAD.n6 4.5005
R1334 PAD.n53 PAD.n6 4.5005
R1335 PAD.n152 PAD.n6 4.5005
R1336 PAD.n54 PAD.n6 4.5005
R1337 PAD.n149 PAD.n6 4.5005
R1338 PAD.n55 PAD.n6 4.5005
R1339 PAD.n146 PAD.n6 4.5005
R1340 PAD.n56 PAD.n6 4.5005
R1341 PAD.n143 PAD.n6 4.5005
R1342 PAD.n57 PAD.n6 4.5005
R1343 PAD.n140 PAD.n6 4.5005
R1344 PAD.n58 PAD.n6 4.5005
R1345 PAD.n137 PAD.n6 4.5005
R1346 PAD.n59 PAD.n6 4.5005
R1347 PAD.n134 PAD.n6 4.5005
R1348 PAD.n60 PAD.n6 4.5005
R1349 PAD.n131 PAD.n6 4.5005
R1350 PAD.n61 PAD.n6 4.5005
R1351 PAD.n128 PAD.n6 4.5005
R1352 PAD.n62 PAD.n6 4.5005
R1353 PAD.n125 PAD.n6 4.5005
R1354 PAD.n63 PAD.n6 4.5005
R1355 PAD.n122 PAD.n6 4.5005
R1356 PAD.n49 PAD.n26 4.5005
R1357 PAD.n163 PAD.n26 4.5005
R1358 PAD.n50 PAD.n26 4.5005
R1359 PAD.n161 PAD.n26 4.5005
R1360 PAD.n51 PAD.n26 4.5005
R1361 PAD.n158 PAD.n26 4.5005
R1362 PAD.n52 PAD.n26 4.5005
R1363 PAD.n155 PAD.n26 4.5005
R1364 PAD.n53 PAD.n26 4.5005
R1365 PAD.n152 PAD.n26 4.5005
R1366 PAD.n54 PAD.n26 4.5005
R1367 PAD.n149 PAD.n26 4.5005
R1368 PAD.n55 PAD.n26 4.5005
R1369 PAD.n146 PAD.n26 4.5005
R1370 PAD.n56 PAD.n26 4.5005
R1371 PAD.n143 PAD.n26 4.5005
R1372 PAD.n57 PAD.n26 4.5005
R1373 PAD.n140 PAD.n26 4.5005
R1374 PAD.n58 PAD.n26 4.5005
R1375 PAD.n137 PAD.n26 4.5005
R1376 PAD.n59 PAD.n26 4.5005
R1377 PAD.n134 PAD.n26 4.5005
R1378 PAD.n60 PAD.n26 4.5005
R1379 PAD.n131 PAD.n26 4.5005
R1380 PAD.n61 PAD.n26 4.5005
R1381 PAD.n128 PAD.n26 4.5005
R1382 PAD.n62 PAD.n26 4.5005
R1383 PAD.n125 PAD.n26 4.5005
R1384 PAD.n63 PAD.n26 4.5005
R1385 PAD.n122 PAD.n26 4.5005
R1386 PAD.n49 PAD.n7 4.5005
R1387 PAD.n163 PAD.n7 4.5005
R1388 PAD.n50 PAD.n7 4.5005
R1389 PAD.n161 PAD.n7 4.5005
R1390 PAD.n51 PAD.n7 4.5005
R1391 PAD.n158 PAD.n7 4.5005
R1392 PAD.n52 PAD.n7 4.5005
R1393 PAD.n155 PAD.n7 4.5005
R1394 PAD.n53 PAD.n7 4.5005
R1395 PAD.n152 PAD.n7 4.5005
R1396 PAD.n54 PAD.n7 4.5005
R1397 PAD.n149 PAD.n7 4.5005
R1398 PAD.n55 PAD.n7 4.5005
R1399 PAD.n146 PAD.n7 4.5005
R1400 PAD.n56 PAD.n7 4.5005
R1401 PAD.n143 PAD.n7 4.5005
R1402 PAD.n57 PAD.n7 4.5005
R1403 PAD.n140 PAD.n7 4.5005
R1404 PAD.n58 PAD.n7 4.5005
R1405 PAD.n137 PAD.n7 4.5005
R1406 PAD.n59 PAD.n7 4.5005
R1407 PAD.n134 PAD.n7 4.5005
R1408 PAD.n60 PAD.n7 4.5005
R1409 PAD.n131 PAD.n7 4.5005
R1410 PAD.n61 PAD.n7 4.5005
R1411 PAD.n128 PAD.n7 4.5005
R1412 PAD.n62 PAD.n7 4.5005
R1413 PAD.n125 PAD.n7 4.5005
R1414 PAD.n63 PAD.n7 4.5005
R1415 PAD.n122 PAD.n7 4.5005
R1416 PAD.n49 PAD.n25 4.5005
R1417 PAD.n163 PAD.n25 4.5005
R1418 PAD.n50 PAD.n25 4.5005
R1419 PAD.n161 PAD.n25 4.5005
R1420 PAD.n51 PAD.n25 4.5005
R1421 PAD.n158 PAD.n25 4.5005
R1422 PAD.n52 PAD.n25 4.5005
R1423 PAD.n155 PAD.n25 4.5005
R1424 PAD.n53 PAD.n25 4.5005
R1425 PAD.n152 PAD.n25 4.5005
R1426 PAD.n54 PAD.n25 4.5005
R1427 PAD.n149 PAD.n25 4.5005
R1428 PAD.n55 PAD.n25 4.5005
R1429 PAD.n146 PAD.n25 4.5005
R1430 PAD.n56 PAD.n25 4.5005
R1431 PAD.n143 PAD.n25 4.5005
R1432 PAD.n57 PAD.n25 4.5005
R1433 PAD.n140 PAD.n25 4.5005
R1434 PAD.n58 PAD.n25 4.5005
R1435 PAD.n137 PAD.n25 4.5005
R1436 PAD.n59 PAD.n25 4.5005
R1437 PAD.n134 PAD.n25 4.5005
R1438 PAD.n60 PAD.n25 4.5005
R1439 PAD.n131 PAD.n25 4.5005
R1440 PAD.n61 PAD.n25 4.5005
R1441 PAD.n128 PAD.n25 4.5005
R1442 PAD.n62 PAD.n25 4.5005
R1443 PAD.n125 PAD.n25 4.5005
R1444 PAD.n63 PAD.n25 4.5005
R1445 PAD.n122 PAD.n25 4.5005
R1446 PAD.n49 PAD.n8 4.5005
R1447 PAD.n163 PAD.n8 4.5005
R1448 PAD.n50 PAD.n8 4.5005
R1449 PAD.n161 PAD.n8 4.5005
R1450 PAD.n51 PAD.n8 4.5005
R1451 PAD.n158 PAD.n8 4.5005
R1452 PAD.n52 PAD.n8 4.5005
R1453 PAD.n155 PAD.n8 4.5005
R1454 PAD.n53 PAD.n8 4.5005
R1455 PAD.n152 PAD.n8 4.5005
R1456 PAD.n54 PAD.n8 4.5005
R1457 PAD.n149 PAD.n8 4.5005
R1458 PAD.n55 PAD.n8 4.5005
R1459 PAD.n146 PAD.n8 4.5005
R1460 PAD.n56 PAD.n8 4.5005
R1461 PAD.n143 PAD.n8 4.5005
R1462 PAD.n57 PAD.n8 4.5005
R1463 PAD.n140 PAD.n8 4.5005
R1464 PAD.n58 PAD.n8 4.5005
R1465 PAD.n137 PAD.n8 4.5005
R1466 PAD.n59 PAD.n8 4.5005
R1467 PAD.n134 PAD.n8 4.5005
R1468 PAD.n60 PAD.n8 4.5005
R1469 PAD.n131 PAD.n8 4.5005
R1470 PAD.n61 PAD.n8 4.5005
R1471 PAD.n128 PAD.n8 4.5005
R1472 PAD.n62 PAD.n8 4.5005
R1473 PAD.n125 PAD.n8 4.5005
R1474 PAD.n63 PAD.n8 4.5005
R1475 PAD.n122 PAD.n8 4.5005
R1476 PAD.n49 PAD.n24 4.5005
R1477 PAD.n163 PAD.n24 4.5005
R1478 PAD.n50 PAD.n24 4.5005
R1479 PAD.n161 PAD.n24 4.5005
R1480 PAD.n51 PAD.n24 4.5005
R1481 PAD.n158 PAD.n24 4.5005
R1482 PAD.n52 PAD.n24 4.5005
R1483 PAD.n155 PAD.n24 4.5005
R1484 PAD.n53 PAD.n24 4.5005
R1485 PAD.n152 PAD.n24 4.5005
R1486 PAD.n54 PAD.n24 4.5005
R1487 PAD.n149 PAD.n24 4.5005
R1488 PAD.n55 PAD.n24 4.5005
R1489 PAD.n146 PAD.n24 4.5005
R1490 PAD.n56 PAD.n24 4.5005
R1491 PAD.n143 PAD.n24 4.5005
R1492 PAD.n57 PAD.n24 4.5005
R1493 PAD.n140 PAD.n24 4.5005
R1494 PAD.n58 PAD.n24 4.5005
R1495 PAD.n137 PAD.n24 4.5005
R1496 PAD.n59 PAD.n24 4.5005
R1497 PAD.n134 PAD.n24 4.5005
R1498 PAD.n60 PAD.n24 4.5005
R1499 PAD.n131 PAD.n24 4.5005
R1500 PAD.n61 PAD.n24 4.5005
R1501 PAD.n128 PAD.n24 4.5005
R1502 PAD.n62 PAD.n24 4.5005
R1503 PAD.n125 PAD.n24 4.5005
R1504 PAD.n63 PAD.n24 4.5005
R1505 PAD.n122 PAD.n24 4.5005
R1506 PAD.n49 PAD.n9 4.5005
R1507 PAD.n163 PAD.n9 4.5005
R1508 PAD.n50 PAD.n9 4.5005
R1509 PAD.n161 PAD.n9 4.5005
R1510 PAD.n51 PAD.n9 4.5005
R1511 PAD.n158 PAD.n9 4.5005
R1512 PAD.n52 PAD.n9 4.5005
R1513 PAD.n155 PAD.n9 4.5005
R1514 PAD.n53 PAD.n9 4.5005
R1515 PAD.n152 PAD.n9 4.5005
R1516 PAD.n54 PAD.n9 4.5005
R1517 PAD.n149 PAD.n9 4.5005
R1518 PAD.n55 PAD.n9 4.5005
R1519 PAD.n146 PAD.n9 4.5005
R1520 PAD.n56 PAD.n9 4.5005
R1521 PAD.n143 PAD.n9 4.5005
R1522 PAD.n57 PAD.n9 4.5005
R1523 PAD.n140 PAD.n9 4.5005
R1524 PAD.n58 PAD.n9 4.5005
R1525 PAD.n137 PAD.n9 4.5005
R1526 PAD.n59 PAD.n9 4.5005
R1527 PAD.n134 PAD.n9 4.5005
R1528 PAD.n60 PAD.n9 4.5005
R1529 PAD.n131 PAD.n9 4.5005
R1530 PAD.n61 PAD.n9 4.5005
R1531 PAD.n128 PAD.n9 4.5005
R1532 PAD.n62 PAD.n9 4.5005
R1533 PAD.n125 PAD.n9 4.5005
R1534 PAD.n63 PAD.n9 4.5005
R1535 PAD.n122 PAD.n9 4.5005
R1536 PAD.n49 PAD.n23 4.5005
R1537 PAD.n163 PAD.n23 4.5005
R1538 PAD.n50 PAD.n23 4.5005
R1539 PAD.n161 PAD.n23 4.5005
R1540 PAD.n51 PAD.n23 4.5005
R1541 PAD.n158 PAD.n23 4.5005
R1542 PAD.n52 PAD.n23 4.5005
R1543 PAD.n155 PAD.n23 4.5005
R1544 PAD.n53 PAD.n23 4.5005
R1545 PAD.n152 PAD.n23 4.5005
R1546 PAD.n54 PAD.n23 4.5005
R1547 PAD.n149 PAD.n23 4.5005
R1548 PAD.n55 PAD.n23 4.5005
R1549 PAD.n146 PAD.n23 4.5005
R1550 PAD.n56 PAD.n23 4.5005
R1551 PAD.n143 PAD.n23 4.5005
R1552 PAD.n57 PAD.n23 4.5005
R1553 PAD.n140 PAD.n23 4.5005
R1554 PAD.n58 PAD.n23 4.5005
R1555 PAD.n137 PAD.n23 4.5005
R1556 PAD.n59 PAD.n23 4.5005
R1557 PAD.n134 PAD.n23 4.5005
R1558 PAD.n60 PAD.n23 4.5005
R1559 PAD.n131 PAD.n23 4.5005
R1560 PAD.n61 PAD.n23 4.5005
R1561 PAD.n128 PAD.n23 4.5005
R1562 PAD.n62 PAD.n23 4.5005
R1563 PAD.n125 PAD.n23 4.5005
R1564 PAD.n63 PAD.n23 4.5005
R1565 PAD.n122 PAD.n23 4.5005
R1566 PAD.n49 PAD.n10 4.5005
R1567 PAD.n163 PAD.n10 4.5005
R1568 PAD.n50 PAD.n10 4.5005
R1569 PAD.n161 PAD.n10 4.5005
R1570 PAD.n51 PAD.n10 4.5005
R1571 PAD.n158 PAD.n10 4.5005
R1572 PAD.n52 PAD.n10 4.5005
R1573 PAD.n155 PAD.n10 4.5005
R1574 PAD.n53 PAD.n10 4.5005
R1575 PAD.n152 PAD.n10 4.5005
R1576 PAD.n54 PAD.n10 4.5005
R1577 PAD.n149 PAD.n10 4.5005
R1578 PAD.n55 PAD.n10 4.5005
R1579 PAD.n146 PAD.n10 4.5005
R1580 PAD.n56 PAD.n10 4.5005
R1581 PAD.n143 PAD.n10 4.5005
R1582 PAD.n57 PAD.n10 4.5005
R1583 PAD.n140 PAD.n10 4.5005
R1584 PAD.n58 PAD.n10 4.5005
R1585 PAD.n137 PAD.n10 4.5005
R1586 PAD.n59 PAD.n10 4.5005
R1587 PAD.n134 PAD.n10 4.5005
R1588 PAD.n60 PAD.n10 4.5005
R1589 PAD.n131 PAD.n10 4.5005
R1590 PAD.n61 PAD.n10 4.5005
R1591 PAD.n128 PAD.n10 4.5005
R1592 PAD.n62 PAD.n10 4.5005
R1593 PAD.n125 PAD.n10 4.5005
R1594 PAD.n63 PAD.n10 4.5005
R1595 PAD.n122 PAD.n10 4.5005
R1596 PAD.n49 PAD.n22 4.5005
R1597 PAD.n163 PAD.n22 4.5005
R1598 PAD.n50 PAD.n22 4.5005
R1599 PAD.n161 PAD.n22 4.5005
R1600 PAD.n51 PAD.n22 4.5005
R1601 PAD.n158 PAD.n22 4.5005
R1602 PAD.n52 PAD.n22 4.5005
R1603 PAD.n155 PAD.n22 4.5005
R1604 PAD.n53 PAD.n22 4.5005
R1605 PAD.n152 PAD.n22 4.5005
R1606 PAD.n54 PAD.n22 4.5005
R1607 PAD.n149 PAD.n22 4.5005
R1608 PAD.n55 PAD.n22 4.5005
R1609 PAD.n146 PAD.n22 4.5005
R1610 PAD.n56 PAD.n22 4.5005
R1611 PAD.n143 PAD.n22 4.5005
R1612 PAD.n57 PAD.n22 4.5005
R1613 PAD.n140 PAD.n22 4.5005
R1614 PAD.n58 PAD.n22 4.5005
R1615 PAD.n137 PAD.n22 4.5005
R1616 PAD.n59 PAD.n22 4.5005
R1617 PAD.n134 PAD.n22 4.5005
R1618 PAD.n60 PAD.n22 4.5005
R1619 PAD.n131 PAD.n22 4.5005
R1620 PAD.n61 PAD.n22 4.5005
R1621 PAD.n128 PAD.n22 4.5005
R1622 PAD.n62 PAD.n22 4.5005
R1623 PAD.n125 PAD.n22 4.5005
R1624 PAD.n63 PAD.n22 4.5005
R1625 PAD.n122 PAD.n22 4.5005
R1626 PAD.n49 PAD.n11 4.5005
R1627 PAD.n163 PAD.n11 4.5005
R1628 PAD.n50 PAD.n11 4.5005
R1629 PAD.n161 PAD.n11 4.5005
R1630 PAD.n51 PAD.n11 4.5005
R1631 PAD.n158 PAD.n11 4.5005
R1632 PAD.n52 PAD.n11 4.5005
R1633 PAD.n155 PAD.n11 4.5005
R1634 PAD.n53 PAD.n11 4.5005
R1635 PAD.n152 PAD.n11 4.5005
R1636 PAD.n54 PAD.n11 4.5005
R1637 PAD.n149 PAD.n11 4.5005
R1638 PAD.n55 PAD.n11 4.5005
R1639 PAD.n146 PAD.n11 4.5005
R1640 PAD.n56 PAD.n11 4.5005
R1641 PAD.n143 PAD.n11 4.5005
R1642 PAD.n57 PAD.n11 4.5005
R1643 PAD.n140 PAD.n11 4.5005
R1644 PAD.n58 PAD.n11 4.5005
R1645 PAD.n137 PAD.n11 4.5005
R1646 PAD.n59 PAD.n11 4.5005
R1647 PAD.n134 PAD.n11 4.5005
R1648 PAD.n60 PAD.n11 4.5005
R1649 PAD.n131 PAD.n11 4.5005
R1650 PAD.n61 PAD.n11 4.5005
R1651 PAD.n128 PAD.n11 4.5005
R1652 PAD.n62 PAD.n11 4.5005
R1653 PAD.n125 PAD.n11 4.5005
R1654 PAD.n63 PAD.n11 4.5005
R1655 PAD.n122 PAD.n11 4.5005
R1656 PAD.n49 PAD.n21 4.5005
R1657 PAD.n163 PAD.n21 4.5005
R1658 PAD.n49 PAD.n12 4.5005
R1659 PAD.n163 PAD.n12 4.5005
R1660 PAD.n50 PAD.n12 4.5005
R1661 PAD.n161 PAD.n12 4.5005
R1662 PAD.n51 PAD.n12 4.5005
R1663 PAD.n158 PAD.n12 4.5005
R1664 PAD.n52 PAD.n12 4.5005
R1665 PAD.n155 PAD.n12 4.5005
R1666 PAD.n53 PAD.n12 4.5005
R1667 PAD.n152 PAD.n12 4.5005
R1668 PAD.n54 PAD.n12 4.5005
R1669 PAD.n149 PAD.n12 4.5005
R1670 PAD.n55 PAD.n12 4.5005
R1671 PAD.n146 PAD.n12 4.5005
R1672 PAD.n56 PAD.n12 4.5005
R1673 PAD.n143 PAD.n12 4.5005
R1674 PAD.n57 PAD.n12 4.5005
R1675 PAD.n140 PAD.n12 4.5005
R1676 PAD.n58 PAD.n12 4.5005
R1677 PAD.n137 PAD.n12 4.5005
R1678 PAD.n59 PAD.n12 4.5005
R1679 PAD.n134 PAD.n12 4.5005
R1680 PAD.n60 PAD.n12 4.5005
R1681 PAD.n131 PAD.n12 4.5005
R1682 PAD.n61 PAD.n12 4.5005
R1683 PAD.n128 PAD.n12 4.5005
R1684 PAD.n62 PAD.n12 4.5005
R1685 PAD.n125 PAD.n12 4.5005
R1686 PAD.n63 PAD.n12 4.5005
R1687 PAD.n122 PAD.n12 4.5005
R1688 PAD.n163 PAD.n13 4.5005
R1689 PAD.n50 PAD.n13 4.5005
R1690 PAD.n161 PAD.n13 4.5005
R1691 PAD.n51 PAD.n13 4.5005
R1692 PAD.n158 PAD.n13 4.5005
R1693 PAD.n52 PAD.n13 4.5005
R1694 PAD.n155 PAD.n13 4.5005
R1695 PAD.n53 PAD.n13 4.5005
R1696 PAD.n152 PAD.n13 4.5005
R1697 PAD.n54 PAD.n13 4.5005
R1698 PAD.n149 PAD.n13 4.5005
R1699 PAD.n55 PAD.n13 4.5005
R1700 PAD.n146 PAD.n13 4.5005
R1701 PAD.n56 PAD.n13 4.5005
R1702 PAD.n143 PAD.n13 4.5005
R1703 PAD.n57 PAD.n13 4.5005
R1704 PAD.n140 PAD.n13 4.5005
R1705 PAD.n58 PAD.n13 4.5005
R1706 PAD.n137 PAD.n13 4.5005
R1707 PAD.n59 PAD.n13 4.5005
R1708 PAD.n134 PAD.n13 4.5005
R1709 PAD.n60 PAD.n13 4.5005
R1710 PAD.n131 PAD.n13 4.5005
R1711 PAD.n61 PAD.n13 4.5005
R1712 PAD.n128 PAD.n13 4.5005
R1713 PAD.n62 PAD.n13 4.5005
R1714 PAD.n125 PAD.n13 4.5005
R1715 PAD.n63 PAD.n13 4.5005
R1716 PAD.n122 PAD.n13 4.5005
R1717 PAD.n77 PAD.n13 4.5005
R1718 PAD.n49 PAD.n19 4.5005
R1719 PAD.n163 PAD.n19 4.5005
R1720 PAD.n50 PAD.n19 4.5005
R1721 PAD.n161 PAD.n19 4.5005
R1722 PAD.n51 PAD.n19 4.5005
R1723 PAD.n158 PAD.n19 4.5005
R1724 PAD.n52 PAD.n19 4.5005
R1725 PAD.n155 PAD.n19 4.5005
R1726 PAD.n53 PAD.n19 4.5005
R1727 PAD.n152 PAD.n19 4.5005
R1728 PAD.n54 PAD.n19 4.5005
R1729 PAD.n149 PAD.n19 4.5005
R1730 PAD.n55 PAD.n19 4.5005
R1731 PAD.n146 PAD.n19 4.5005
R1732 PAD.n56 PAD.n19 4.5005
R1733 PAD.n143 PAD.n19 4.5005
R1734 PAD.n57 PAD.n19 4.5005
R1735 PAD.n140 PAD.n19 4.5005
R1736 PAD.n58 PAD.n19 4.5005
R1737 PAD.n137 PAD.n19 4.5005
R1738 PAD.n59 PAD.n19 4.5005
R1739 PAD.n134 PAD.n19 4.5005
R1740 PAD.n60 PAD.n19 4.5005
R1741 PAD.n131 PAD.n19 4.5005
R1742 PAD.n61 PAD.n19 4.5005
R1743 PAD.n128 PAD.n19 4.5005
R1744 PAD.n62 PAD.n19 4.5005
R1745 PAD.n125 PAD.n19 4.5005
R1746 PAD.n63 PAD.n19 4.5005
R1747 PAD.n122 PAD.n19 4.5005
R1748 PAD.n49 PAD.n14 4.5005
R1749 PAD.n163 PAD.n14 4.5005
R1750 PAD.n50 PAD.n14 4.5005
R1751 PAD.n161 PAD.n14 4.5005
R1752 PAD.n51 PAD.n14 4.5005
R1753 PAD.n158 PAD.n14 4.5005
R1754 PAD.n52 PAD.n14 4.5005
R1755 PAD.n155 PAD.n14 4.5005
R1756 PAD.n53 PAD.n14 4.5005
R1757 PAD.n152 PAD.n14 4.5005
R1758 PAD.n54 PAD.n14 4.5005
R1759 PAD.n149 PAD.n14 4.5005
R1760 PAD.n55 PAD.n14 4.5005
R1761 PAD.n146 PAD.n14 4.5005
R1762 PAD.n56 PAD.n14 4.5005
R1763 PAD.n143 PAD.n14 4.5005
R1764 PAD.n57 PAD.n14 4.5005
R1765 PAD.n140 PAD.n14 4.5005
R1766 PAD.n58 PAD.n14 4.5005
R1767 PAD.n137 PAD.n14 4.5005
R1768 PAD.n59 PAD.n14 4.5005
R1769 PAD.n134 PAD.n14 4.5005
R1770 PAD.n60 PAD.n14 4.5005
R1771 PAD.n131 PAD.n14 4.5005
R1772 PAD.n61 PAD.n14 4.5005
R1773 PAD.n128 PAD.n14 4.5005
R1774 PAD.n62 PAD.n14 4.5005
R1775 PAD.n125 PAD.n14 4.5005
R1776 PAD.n63 PAD.n14 4.5005
R1777 PAD.n122 PAD.n14 4.5005
R1778 PAD.n49 PAD.n18 4.5005
R1779 PAD.n163 PAD.n18 4.5005
R1780 PAD.n50 PAD.n18 4.5005
R1781 PAD.n161 PAD.n18 4.5005
R1782 PAD.n51 PAD.n18 4.5005
R1783 PAD.n158 PAD.n18 4.5005
R1784 PAD.n52 PAD.n18 4.5005
R1785 PAD.n155 PAD.n18 4.5005
R1786 PAD.n53 PAD.n18 4.5005
R1787 PAD.n152 PAD.n18 4.5005
R1788 PAD.n54 PAD.n18 4.5005
R1789 PAD.n149 PAD.n18 4.5005
R1790 PAD.n55 PAD.n18 4.5005
R1791 PAD.n146 PAD.n18 4.5005
R1792 PAD.n56 PAD.n18 4.5005
R1793 PAD.n143 PAD.n18 4.5005
R1794 PAD.n57 PAD.n18 4.5005
R1795 PAD.n140 PAD.n18 4.5005
R1796 PAD.n58 PAD.n18 4.5005
R1797 PAD.n137 PAD.n18 4.5005
R1798 PAD.n59 PAD.n18 4.5005
R1799 PAD.n134 PAD.n18 4.5005
R1800 PAD.n60 PAD.n18 4.5005
R1801 PAD.n131 PAD.n18 4.5005
R1802 PAD.n61 PAD.n18 4.5005
R1803 PAD.n128 PAD.n18 4.5005
R1804 PAD.n62 PAD.n18 4.5005
R1805 PAD.n125 PAD.n18 4.5005
R1806 PAD.n63 PAD.n18 4.5005
R1807 PAD.n122 PAD.n18 4.5005
R1808 PAD.n49 PAD.n15 4.5005
R1809 PAD.n163 PAD.n15 4.5005
R1810 PAD.n50 PAD.n15 4.5005
R1811 PAD.n161 PAD.n15 4.5005
R1812 PAD.n51 PAD.n15 4.5005
R1813 PAD.n158 PAD.n15 4.5005
R1814 PAD.n52 PAD.n15 4.5005
R1815 PAD.n155 PAD.n15 4.5005
R1816 PAD.n53 PAD.n15 4.5005
R1817 PAD.n152 PAD.n15 4.5005
R1818 PAD.n54 PAD.n15 4.5005
R1819 PAD.n149 PAD.n15 4.5005
R1820 PAD.n55 PAD.n15 4.5005
R1821 PAD.n146 PAD.n15 4.5005
R1822 PAD.n56 PAD.n15 4.5005
R1823 PAD.n143 PAD.n15 4.5005
R1824 PAD.n57 PAD.n15 4.5005
R1825 PAD.n140 PAD.n15 4.5005
R1826 PAD.n58 PAD.n15 4.5005
R1827 PAD.n137 PAD.n15 4.5005
R1828 PAD.n59 PAD.n15 4.5005
R1829 PAD.n134 PAD.n15 4.5005
R1830 PAD.n60 PAD.n15 4.5005
R1831 PAD.n131 PAD.n15 4.5005
R1832 PAD.n61 PAD.n15 4.5005
R1833 PAD.n128 PAD.n15 4.5005
R1834 PAD.n62 PAD.n15 4.5005
R1835 PAD.n125 PAD.n15 4.5005
R1836 PAD.n63 PAD.n15 4.5005
R1837 PAD.n122 PAD.n15 4.5005
R1838 PAD.n254 PAD.n49 4.5005
R1839 PAD.n254 PAD.n163 4.5005
R1840 PAD.n254 PAD.n50 4.5005
R1841 PAD.n254 PAD.n161 4.5005
R1842 PAD.n254 PAD.n51 4.5005
R1843 PAD.n254 PAD.n158 4.5005
R1844 PAD.n254 PAD.n52 4.5005
R1845 PAD.n254 PAD.n155 4.5005
R1846 PAD.n254 PAD.n53 4.5005
R1847 PAD.n254 PAD.n152 4.5005
R1848 PAD.n254 PAD.n54 4.5005
R1849 PAD.n254 PAD.n149 4.5005
R1850 PAD.n254 PAD.n55 4.5005
R1851 PAD.n254 PAD.n146 4.5005
R1852 PAD.n254 PAD.n56 4.5005
R1853 PAD.n254 PAD.n143 4.5005
R1854 PAD.n254 PAD.n57 4.5005
R1855 PAD.n254 PAD.n140 4.5005
R1856 PAD.n254 PAD.n58 4.5005
R1857 PAD.n254 PAD.n137 4.5005
R1858 PAD.n254 PAD.n59 4.5005
R1859 PAD.n254 PAD.n134 4.5005
R1860 PAD.n254 PAD.n60 4.5005
R1861 PAD.n254 PAD.n131 4.5005
R1862 PAD.n254 PAD.n61 4.5005
R1863 PAD.n254 PAD.n128 4.5005
R1864 PAD.n254 PAD.n62 4.5005
R1865 PAD.n254 PAD.n125 4.5005
R1866 PAD.n254 PAD.n63 4.5005
R1867 PAD.n254 PAD.n122 4.5005
R1868 PAD.n49 PAD.n16 4.5005
R1869 PAD.n163 PAD.n16 4.5005
R1870 PAD.n50 PAD.n16 4.5005
R1871 PAD.n161 PAD.n16 4.5005
R1872 PAD.n51 PAD.n16 4.5005
R1873 PAD.n158 PAD.n16 4.5005
R1874 PAD.n52 PAD.n16 4.5005
R1875 PAD.n155 PAD.n16 4.5005
R1876 PAD.n53 PAD.n16 4.5005
R1877 PAD.n152 PAD.n16 4.5005
R1878 PAD.n54 PAD.n16 4.5005
R1879 PAD.n149 PAD.n16 4.5005
R1880 PAD.n55 PAD.n16 4.5005
R1881 PAD.n146 PAD.n16 4.5005
R1882 PAD.n56 PAD.n16 4.5005
R1883 PAD.n143 PAD.n16 4.5005
R1884 PAD.n57 PAD.n16 4.5005
R1885 PAD.n140 PAD.n16 4.5005
R1886 PAD.n58 PAD.n16 4.5005
R1887 PAD.n137 PAD.n16 4.5005
R1888 PAD.n59 PAD.n16 4.5005
R1889 PAD.n134 PAD.n16 4.5005
R1890 PAD.n60 PAD.n16 4.5005
R1891 PAD.n131 PAD.n16 4.5005
R1892 PAD.n61 PAD.n16 4.5005
R1893 PAD.n128 PAD.n16 4.5005
R1894 PAD.n62 PAD.n16 4.5005
R1895 PAD.n125 PAD.n16 4.5005
R1896 PAD.n63 PAD.n16 4.5005
R1897 PAD.n122 PAD.n16 4.5005
R1898 PAD.n207 PAD.n16 4.5005
R1899 PAD.n228 PAD.n15 2.2503
R1900 PAD.n222 PAD.n15 2.2503
R1901 PAD.n254 PAD.n17 2.2503
R1902 PAD.n254 PAD.n240 2.2503
R1903 PAD.n254 PAD.n253 2.2503
R1904 PAD.n254 PAD.n241 2.2503
R1905 PAD.n254 PAD.n242 2.2503
R1906 PAD.n254 PAD.n243 2.2503
R1907 PAD.n254 PAD.n244 2.2503
R1908 PAD.n254 PAD.n252 2.2503
R1909 PAD.n254 PAD.n251 2.2503
R1910 PAD.n254 PAD.n245 2.2503
R1911 PAD.n254 PAD.n250 2.2503
R1912 PAD.n254 PAD.n249 2.2503
R1913 PAD.n254 PAD.n246 2.2503
R1914 PAD.n254 PAD.n248 2.2503
R1915 PAD.n237 PAD.n16 2.2503
R1916 PAD.n235 PAD.n16 2.2503
R1917 PAD.n231 PAD.n16 2.2503
R1918 PAD.n229 PAD.n16 2.2503
R1919 PAD.n226 PAD.n16 2.2503
R1920 PAD.n224 PAD.n16 2.2503
R1921 PAD.n220 PAD.n16 2.2503
R1922 PAD.n218 PAD.n16 2.2503
R1923 PAD.n216 PAD.n16 2.2503
R1924 PAD.n214 PAD.n16 2.2503
R1925 PAD.n212 PAD.n16 2.2503
R1926 PAD.n210 PAD.n16 2.2503
R1927 PAD.n208 PAD.n16 2.2503
R1928 PAD.n255 PAD.n16 2.2503
R1929 PAD.n77 PAD.n76 2.2503
R1930 PAD.n77 PAD.n64 2.2503
R1931 PAD.n207 PAD.n164 2.2503
R1932 PAD.n207 PAD.n165 2.2503
R1933 PAD.n122 PAD.n120 2.2503
R1934 PAD.n77 PAD.n65 2.2503
R1935 PAD.n207 PAD.n166 2.2503
R1936 PAD.n77 PAD.n66 2.2503
R1937 PAD.n77 PAD.n75 2.2503
R1938 PAD.n207 PAD.n167 2.2503
R1939 PAD.n77 PAD.n74 2.2503
R1940 PAD.n207 PAD.n168 2.2503
R1941 PAD.n207 PAD.n169 2.2503
R1942 PAD.n77 PAD.n73 2.2503
R1943 PAD.n77 PAD.n72 2.2503
R1944 PAD.n207 PAD.n170 2.2503
R1945 PAD.n77 PAD.n71 2.2503
R1946 PAD.n207 PAD.n171 2.2503
R1947 PAD.n77 PAD.n70 2.2503
R1948 PAD.n207 PAD.n172 2.2503
R1949 PAD.n160 PAD.n21 2.2503
R1950 PAD.n157 PAD.n21 2.2503
R1951 PAD.n154 PAD.n21 2.2503
R1952 PAD.n151 PAD.n21 2.2503
R1953 PAD.n148 PAD.n21 2.2503
R1954 PAD.n145 PAD.n21 2.2503
R1955 PAD.n142 PAD.n21 2.2503
R1956 PAD.n139 PAD.n21 2.2503
R1957 PAD.n136 PAD.n21 2.2503
R1958 PAD.n133 PAD.n21 2.2503
R1959 PAD.n130 PAD.n21 2.2503
R1960 PAD.n127 PAD.n21 2.2503
R1961 PAD.n124 PAD.n21 2.2503
R1962 PAD.n121 PAD.n21 2.2503
R1963 PAD.n77 PAD.n69 2.2503
R1964 PAD.n207 PAD.n173 2.2503
R1965 PAD.n49 PAD.n48 2.2503
R1966 PAD.n162 PAD.n20 2.2503
R1967 PAD.n159 PAD.n20 2.2503
R1968 PAD.n156 PAD.n20 2.2503
R1969 PAD.n153 PAD.n20 2.2503
R1970 PAD.n150 PAD.n20 2.2503
R1971 PAD.n147 PAD.n20 2.2503
R1972 PAD.n144 PAD.n20 2.2503
R1973 PAD.n141 PAD.n20 2.2503
R1974 PAD.n138 PAD.n20 2.2503
R1975 PAD.n135 PAD.n20 2.2503
R1976 PAD.n132 PAD.n20 2.2503
R1977 PAD.n129 PAD.n20 2.2503
R1978 PAD.n126 PAD.n20 2.2503
R1979 PAD.n123 PAD.n20 2.2503
R1980 PAD.n119 PAD.n20 2.2503
R1981 PAD.n207 PAD.n174 2.2503
R1982 PAD.n207 PAD.n175 2.2503
R1983 PAD.n77 PAD.n67 2.2503
R1984 PAD.n77 PAD.n68 2.2503
R1985 PAD.n207 PAD.n176 2.2503
R1986 PAD.n247 PAD.n77 2.2503
R1987 PAD.n239 PAD.n207 2.2503
R1988 PAD.n118 PAD.n116 2.03193
R1989 PAD PAD.n290 1.3199
R1990 PAD.n290 PAD 1.3199
R1991 PAD.n290 PAD 1.3199
R1992 PAD.n114 PAD.t24 0.8195
R1993 PAD.n114 PAD.t8 0.8195
R1994 PAD.n97 PAD.t1 0.8195
R1995 PAD.n97 PAD.t5 0.8195
R1996 PAD.n98 PAD.t18 0.8195
R1997 PAD.n98 PAD.t23 0.8195
R1998 PAD.n99 PAD.t34 0.8195
R1999 PAD.n99 PAD.t27 0.8195
R2000 PAD.n100 PAD.t6 0.8195
R2001 PAD.n100 PAD.t38 0.8195
R2002 PAD.n101 PAD.t14 0.8195
R2003 PAD.n101 PAD.t40 0.8195
R2004 PAD.n102 PAD.t29 0.8195
R2005 PAD.n102 PAD.t35 0.8195
R2006 PAD.n103 PAD.t37 0.8195
R2007 PAD.n103 PAD.t28 0.8195
R2008 PAD.n104 PAD.t31 0.8195
R2009 PAD.n104 PAD.t36 0.8195
R2010 PAD.n105 PAD.t39 0.8195
R2011 PAD.n105 PAD.t30 0.8195
R2012 PAD.n92 PAD.t2 0.8195
R2013 PAD.n92 PAD.t13 0.8195
R2014 PAD.n91 PAD.t17 0.8195
R2015 PAD.n91 PAD.t25 0.8195
R2016 PAD.n90 PAD.t16 0.8195
R2017 PAD.n90 PAD.t26 0.8195
R2018 PAD.n89 PAD.t3 0.8195
R2019 PAD.n89 PAD.t7 0.8195
R2020 PAD.n78 PAD.t19 0.8195
R2021 PAD.n78 PAD.t4 0.8195
R2022 PAD.n79 PAD.t10 0.8195
R2023 PAD.n79 PAD.t21 0.8195
R2024 PAD.n80 PAD.t15 0.8195
R2025 PAD.n80 PAD.t20 0.8195
R2026 PAD.n81 PAD.t32 0.8195
R2027 PAD.n81 PAD.t0 0.8195
R2028 PAD.n82 PAD.t22 0.8195
R2029 PAD.n82 PAD.t33 0.8195
R2030 PAD.n83 PAD.t11 0.8195
R2031 PAD.n83 PAD.t12 0.8195
R2032 PAD.n113 PAD.n112 0.3605
R2033 PAD.n112 PAD.n111 0.3605
R2034 PAD.n111 PAD.n110 0.3605
R2035 PAD.n110 PAD.n109 0.3605
R2036 PAD.n109 PAD.n108 0.3605
R2037 PAD.n108 PAD.n107 0.3605
R2038 PAD.n107 PAD.n106 0.3605
R2039 PAD.n94 PAD.n93 0.3605
R2040 PAD.n95 PAD.n94 0.3605
R2041 PAD.n88 PAD.n87 0.3605
R2042 PAD.n87 PAD.n86 0.3605
R2043 PAD.n86 PAD.n85 0.3605
R2044 PAD.n85 PAD.n84 0.3605
R2045 PAD.n96 PAD.n88 0.3335
R2046 PAD PAD.t9 0.280213
R2047 PAD.n284 PAD.n47 0.141125
R2048 PAD.n283 PAD.n209 0.141125
R2049 PAD.n282 PAD.n46 0.141125
R2050 PAD.n281 PAD.n211 0.141125
R2051 PAD.n280 PAD.n45 0.141125
R2052 PAD.n279 PAD.n213 0.141125
R2053 PAD.n278 PAD.n44 0.141125
R2054 PAD.n277 PAD.n215 0.141125
R2055 PAD.n276 PAD.n43 0.141125
R2056 PAD.n275 PAD.n217 0.141125
R2057 PAD.n274 PAD.n42 0.141125
R2058 PAD.n273 PAD.n219 0.141125
R2059 PAD.n272 PAD.n41 0.141125
R2060 PAD.n271 PAD.n221 0.141125
R2061 PAD.n270 PAD.n40 0.141125
R2062 PAD.n269 PAD.n223 0.141125
R2063 PAD.n268 PAD.n39 0.141125
R2064 PAD.n267 PAD.n225 0.141125
R2065 PAD.n266 PAD.n38 0.141125
R2066 PAD.n265 PAD.n227 0.141125
R2067 PAD.n264 PAD.n37 0.141125
R2068 PAD.n263 PAD.n230 0.141125
R2069 PAD.n262 PAD.n36 0.141125
R2070 PAD.n261 PAD.n232 0.141125
R2071 PAD.n260 PAD.n35 0.141125
R2072 PAD.n259 PAD.n234 0.141125
R2073 PAD.n258 PAD.n34 0.141125
R2074 PAD.n257 PAD.n236 0.141125
R2075 PAD.n256 PAD.n33 0.141125
R2076 PAD.n238 PAD.n0 0.141125
R2077 PAD.n289 PAD.n288 0.141125
R2078 PAD.n178 PAD.n50 0.141125
R2079 PAD.n179 PAD.n161 0.141125
R2080 PAD.n180 PAD.n51 0.141125
R2081 PAD.n181 PAD.n158 0.141125
R2082 PAD.n182 PAD.n52 0.141125
R2083 PAD.n183 PAD.n155 0.141125
R2084 PAD.n184 PAD.n53 0.141125
R2085 PAD.n185 PAD.n152 0.141125
R2086 PAD.n186 PAD.n54 0.141125
R2087 PAD.n187 PAD.n149 0.141125
R2088 PAD.n188 PAD.n55 0.141125
R2089 PAD.n189 PAD.n146 0.141125
R2090 PAD.n190 PAD.n56 0.141125
R2091 PAD.n191 PAD.n143 0.141125
R2092 PAD.n192 PAD.n57 0.141125
R2093 PAD.n193 PAD.n140 0.141125
R2094 PAD.n194 PAD.n58 0.141125
R2095 PAD.n195 PAD.n137 0.141125
R2096 PAD.n196 PAD.n59 0.141125
R2097 PAD.n197 PAD.n134 0.141125
R2098 PAD.n198 PAD.n60 0.141125
R2099 PAD.n199 PAD.n131 0.141125
R2100 PAD.n200 PAD.n61 0.141125
R2101 PAD.n201 PAD.n128 0.141125
R2102 PAD.n202 PAD.n62 0.141125
R2103 PAD.n203 PAD.n125 0.141125
R2104 PAD.n204 PAD.n63 0.141125
R2105 PAD.n205 PAD.n122 0.141125
R2106 PAD.n285 PAD.n284 0.140157
R2107 PAD.n115 PAD.n113 0.131
R2108 PAD.n178 PAD.n177 0.0721774
R2109 PAD.n206 PAD.n205 0.0721774
R2110 PAD.n96 PAD.n95 0.0275
R2111 PAD PAD.t43 0.0251094
R2112 PAD PAD.t44 0.0251094
R2113 PAD PAD.t45 0.0208125
R2114 PAD.n289 PAD.n0 0.0033125
R2115 PAD.n256 PAD.n0 0.0033125
R2116 PAD.n257 PAD.n256 0.0033125
R2117 PAD.n258 PAD.n257 0.0033125
R2118 PAD.n259 PAD.n258 0.0033125
R2119 PAD.n260 PAD.n259 0.0033125
R2120 PAD.n261 PAD.n260 0.0033125
R2121 PAD.n262 PAD.n261 0.0033125
R2122 PAD.n263 PAD.n262 0.0033125
R2123 PAD.n264 PAD.n263 0.0033125
R2124 PAD.n265 PAD.n264 0.0033125
R2125 PAD.n266 PAD.n265 0.0033125
R2126 PAD.n267 PAD.n266 0.0033125
R2127 PAD.n268 PAD.n267 0.0033125
R2128 PAD.n269 PAD.n268 0.0033125
R2129 PAD.n270 PAD.n269 0.0033125
R2130 PAD.n271 PAD.n270 0.0033125
R2131 PAD.n272 PAD.n271 0.0033125
R2132 PAD.n273 PAD.n272 0.0033125
R2133 PAD.n274 PAD.n273 0.0033125
R2134 PAD.n275 PAD.n274 0.0033125
R2135 PAD.n276 PAD.n275 0.0033125
R2136 PAD.n277 PAD.n276 0.0033125
R2137 PAD.n278 PAD.n277 0.0033125
R2138 PAD.n279 PAD.n278 0.0033125
R2139 PAD.n280 PAD.n279 0.0033125
R2140 PAD.n281 PAD.n280 0.0033125
R2141 PAD.n282 PAD.n281 0.0033125
R2142 PAD.n283 PAD.n282 0.0033125
R2143 PAD.n284 PAD.n283 0.0033125
R2144 PAD.n234 PAD.n233 0.00256719
R2145 PAD.n287 PAD.n32 0.00256719
R2146 PAD.n230 PAD.n228 0.00240581
R2147 PAD.n222 PAD.n39 0.00240581
R2148 PAD.n288 PAD.n17 0.00240581
R2149 PAD.n240 PAD.n33 0.00240581
R2150 PAD.n253 PAD.n234 0.00240581
R2151 PAD.n241 PAD.n36 0.00240581
R2152 PAD.n242 PAD.n37 0.00240581
R2153 PAD.n243 PAD.n38 0.00240581
R2154 PAD.n244 PAD.n40 0.00240581
R2155 PAD.n252 PAD.n221 0.00240581
R2156 PAD.n251 PAD.n219 0.00240581
R2157 PAD.n245 PAD.n43 0.00240581
R2158 PAD.n250 PAD.n215 0.00240581
R2159 PAD.n249 PAD.n213 0.00240581
R2160 PAD.n246 PAD.n46 0.00240581
R2161 PAD.n248 PAD.n209 0.00240581
R2162 PAD.n237 PAD.n33 0.00240581
R2163 PAD.n235 PAD.n34 0.00240581
R2164 PAD.n232 PAD.n231 0.00240581
R2165 PAD.n230 PAD.n229 0.00240581
R2166 PAD.n227 PAD.n226 0.00240581
R2167 PAD.n224 PAD.n39 0.00240581
R2168 PAD.n220 PAD.n40 0.00240581
R2169 PAD.n219 PAD.n218 0.00240581
R2170 PAD.n217 PAD.n216 0.00240581
R2171 PAD.n214 PAD.n43 0.00240581
R2172 PAD.n212 PAD.n44 0.00240581
R2173 PAD.n211 PAD.n210 0.00240581
R2174 PAD.n209 PAD.n208 0.00240581
R2175 PAD.n286 PAD.n255 0.00240581
R2176 PAD.n238 PAD.n17 0.00240581
R2177 PAD.n238 PAD.n237 0.00240581
R2178 PAD.n240 PAD.n236 0.00240581
R2179 PAD.n236 PAD.n235 0.00240581
R2180 PAD.n253 PAD.n34 0.00240581
R2181 PAD.n231 PAD.n35 0.00240581
R2182 PAD.n241 PAD.n232 0.00240581
R2183 PAD.n228 PAD.n36 0.00240581
R2184 PAD.n229 PAD.n37 0.00240581
R2185 PAD.n242 PAD.n227 0.00240581
R2186 PAD.n226 PAD.n38 0.00240581
R2187 PAD.n243 PAD.n225 0.00240581
R2188 PAD.n225 PAD.n224 0.00240581
R2189 PAD.n223 PAD.n222 0.00240581
R2190 PAD.n244 PAD.n223 0.00240581
R2191 PAD.n221 PAD.n220 0.00240581
R2192 PAD.n252 PAD.n41 0.00240581
R2193 PAD.n218 PAD.n41 0.00240581
R2194 PAD.n251 PAD.n42 0.00240581
R2195 PAD.n216 PAD.n42 0.00240581
R2196 PAD.n245 PAD.n217 0.00240581
R2197 PAD.n215 PAD.n214 0.00240581
R2198 PAD.n250 PAD.n44 0.00240581
R2199 PAD.n213 PAD.n212 0.00240581
R2200 PAD.n249 PAD.n45 0.00240581
R2201 PAD.n210 PAD.n45 0.00240581
R2202 PAD.n246 PAD.n211 0.00240581
R2203 PAD.n208 PAD.n46 0.00240581
R2204 PAD.n248 PAD.n47 0.00240581
R2205 PAD.n255 PAD.n47 0.00240581
R2206 PAD.n76 PAD.n1 0.00240581
R2207 PAD.n164 PAD.n31 0.00240581
R2208 PAD.n64 PAD.n30 0.00240581
R2209 PAD.n165 PAD.n3 0.00240581
R2210 PAD.n120 PAD.n29 0.00240581
R2211 PAD.n65 PAD.n29 0.00240581
R2212 PAD.n166 PAD.n4 0.00240581
R2213 PAD.n66 PAD.n28 0.00240581
R2214 PAD.n167 PAD.n5 0.00240581
R2215 PAD.n75 PAD.n6 0.00240581
R2216 PAD.n168 PAD.n6 0.00240581
R2217 PAD.n74 PAD.n7 0.00240581
R2218 PAD.n169 PAD.n25 0.00240581
R2219 PAD.n73 PAD.n8 0.00240581
R2220 PAD.n170 PAD.n8 0.00240581
R2221 PAD.n72 PAD.n9 0.00240581
R2222 PAD.n171 PAD.n9 0.00240581
R2223 PAD.n71 PAD.n10 0.00240581
R2224 PAD.n172 PAD.n10 0.00240581
R2225 PAD.n70 PAD.n11 0.00240581
R2226 PAD.n173 PAD.n11 0.00240581
R2227 PAD.n161 PAD.n160 0.00240581
R2228 PAD.n158 PAD.n157 0.00240581
R2229 PAD.n155 PAD.n154 0.00240581
R2230 PAD.n152 PAD.n151 0.00240581
R2231 PAD.n149 PAD.n148 0.00240581
R2232 PAD.n146 PAD.n145 0.00240581
R2233 PAD.n143 PAD.n142 0.00240581
R2234 PAD.n140 PAD.n139 0.00240581
R2235 PAD.n137 PAD.n136 0.00240581
R2236 PAD.n134 PAD.n133 0.00240581
R2237 PAD.n131 PAD.n130 0.00240581
R2238 PAD.n128 PAD.n127 0.00240581
R2239 PAD.n125 PAD.n124 0.00240581
R2240 PAD.n122 PAD.n121 0.00240581
R2241 PAD.n69 PAD.n12 0.00240581
R2242 PAD.n174 PAD.n12 0.00240581
R2243 PAD.n162 PAD.n50 0.00240581
R2244 PAD.n159 PAD.n51 0.00240581
R2245 PAD.n156 PAD.n52 0.00240581
R2246 PAD.n153 PAD.n53 0.00240581
R2247 PAD.n150 PAD.n54 0.00240581
R2248 PAD.n147 PAD.n55 0.00240581
R2249 PAD.n144 PAD.n56 0.00240581
R2250 PAD.n141 PAD.n57 0.00240581
R2251 PAD.n138 PAD.n58 0.00240581
R2252 PAD.n135 PAD.n59 0.00240581
R2253 PAD.n132 PAD.n60 0.00240581
R2254 PAD.n129 PAD.n61 0.00240581
R2255 PAD.n126 PAD.n62 0.00240581
R2256 PAD.n123 PAD.n63 0.00240581
R2257 PAD.n119 PAD.n77 0.00240581
R2258 PAD.n48 PAD.n13 0.00240581
R2259 PAD.n67 PAD.n19 0.00240581
R2260 PAD.n175 PAD.n19 0.00240581
R2261 PAD.n176 PAD.n14 0.00240581
R2262 PAD.n68 PAD.n15 0.00240581
R2263 PAD.n239 PAD.n15 0.00240581
R2264 PAD.n247 PAD.n16 0.00240581
R2265 PAD.n254 PAD.n247 0.00240581
R2266 PAD.n254 PAD.n239 0.00240581
R2267 PAD.n68 PAD.n18 0.00240581
R2268 PAD.n176 PAD.n18 0.00240581
R2269 PAD.n67 PAD.n14 0.00240581
R2270 PAD.n175 PAD.n13 0.00240581
R2271 PAD.n48 PAD.n20 0.00240581
R2272 PAD.n174 PAD.n20 0.00240581
R2273 PAD.n69 PAD.n21 0.00240581
R2274 PAD.n173 PAD.n21 0.00240581
R2275 PAD.n70 PAD.n22 0.00240581
R2276 PAD.n172 PAD.n22 0.00240581
R2277 PAD.n71 PAD.n23 0.00240581
R2278 PAD.n171 PAD.n23 0.00240581
R2279 PAD.n72 PAD.n24 0.00240581
R2280 PAD.n170 PAD.n24 0.00240581
R2281 PAD.n73 PAD.n25 0.00240581
R2282 PAD.n169 PAD.n7 0.00240581
R2283 PAD.n74 PAD.n26 0.00240581
R2284 PAD.n168 PAD.n26 0.00240581
R2285 PAD.n75 PAD.n27 0.00240581
R2286 PAD.n167 PAD.n27 0.00240581
R2287 PAD.n66 PAD.n5 0.00240581
R2288 PAD.n166 PAD.n28 0.00240581
R2289 PAD.n65 PAD.n4 0.00240581
R2290 PAD.n120 PAD.n3 0.00240581
R2291 PAD.n165 PAD.n30 0.00240581
R2292 PAD.n64 PAD.n2 0.00240581
R2293 PAD.n164 PAD.n2 0.00240581
R2294 PAD.n76 PAD.n31 0.00240581
R2295 PAD.n163 PAD.n162 0.00240581
R2296 PAD.n160 PAD.n50 0.00240581
R2297 PAD.n161 PAD.n159 0.00240581
R2298 PAD.n157 PAD.n51 0.00240581
R2299 PAD.n158 PAD.n156 0.00240581
R2300 PAD.n154 PAD.n52 0.00240581
R2301 PAD.n155 PAD.n153 0.00240581
R2302 PAD.n151 PAD.n53 0.00240581
R2303 PAD.n152 PAD.n150 0.00240581
R2304 PAD.n148 PAD.n54 0.00240581
R2305 PAD.n149 PAD.n147 0.00240581
R2306 PAD.n145 PAD.n55 0.00240581
R2307 PAD.n146 PAD.n144 0.00240581
R2308 PAD.n142 PAD.n56 0.00240581
R2309 PAD.n143 PAD.n141 0.00240581
R2310 PAD.n139 PAD.n57 0.00240581
R2311 PAD.n140 PAD.n138 0.00240581
R2312 PAD.n136 PAD.n58 0.00240581
R2313 PAD.n137 PAD.n135 0.00240581
R2314 PAD.n133 PAD.n59 0.00240581
R2315 PAD.n134 PAD.n132 0.00240581
R2316 PAD.n130 PAD.n60 0.00240581
R2317 PAD.n131 PAD.n129 0.00240581
R2318 PAD.n127 PAD.n61 0.00240581
R2319 PAD.n128 PAD.n126 0.00240581
R2320 PAD.n124 PAD.n62 0.00240581
R2321 PAD.n125 PAD.n123 0.00240581
R2322 PAD.n121 PAD.n63 0.00240581
R2323 PAD.n122 PAD.n119 0.00240581
R2324 PAD.n177 PAD.n49 0.00239855
R2325 PAD.n207 PAD.n206 0.00239855
R2326 PAD.n177 PAD.n163 0.00238623
R2327 PAD.n206 PAD.n77 0.00238623
R2328 PAD.n179 PAD.n178 0.00175
R2329 PAD.n180 PAD.n179 0.00175
R2330 PAD.n181 PAD.n180 0.00175
R2331 PAD.n182 PAD.n181 0.00175
R2332 PAD.n183 PAD.n182 0.00175
R2333 PAD.n184 PAD.n183 0.00175
R2334 PAD.n185 PAD.n184 0.00175
R2335 PAD.n186 PAD.n185 0.00175
R2336 PAD.n187 PAD.n186 0.00175
R2337 PAD.n188 PAD.n187 0.00175
R2338 PAD.n189 PAD.n188 0.00175
R2339 PAD.n190 PAD.n189 0.00175
R2340 PAD.n191 PAD.n190 0.00175
R2341 PAD.n192 PAD.n191 0.00175
R2342 PAD.n193 PAD.n192 0.00175
R2343 PAD.n194 PAD.n193 0.00175
R2344 PAD.n195 PAD.n194 0.00175
R2345 PAD.n196 PAD.n195 0.00175
R2346 PAD.n197 PAD.n196 0.00175
R2347 PAD.n198 PAD.n197 0.00175
R2348 PAD.n199 PAD.n198 0.00175
R2349 PAD.n200 PAD.n199 0.00175
R2350 PAD.n201 PAD.n200 0.00175
R2351 PAD.n202 PAD.n201 0.00175
R2352 PAD.n203 PAD.n202 0.00175
R2353 PAD.n204 PAD.n203 0.00175
R2354 PAD.n205 PAD.n204 0.00175
R2355 PAD.n233 PAD.n35 0.00124531
R2356 PAD.n290 PAD.n289 0.00124531
R2357 PAD.n287 PAD.n118 0.00124531
R2358 PAD.n32 PAD.n16 0.00124531
R2359 PAD.n286 PAD.n285 0.00102002
R2360 GN.n0 GN.t2 44.2698
R2361 GN.n40 GN.n39 38.8567
R2362 GN.n40 GN.n38 38.2238
R2363 GN.n0 GN.t3 32.5898
R2364 GN.n1 GN.t4 32.5898
R2365 GN.n2 GN.t5 32.5898
R2366 GN.n3 GN.t6 32.5898
R2367 GN.n4 GN.t7 32.5898
R2368 GN.n5 GN.t8 32.5898
R2369 GN.n6 GN.t9 32.5898
R2370 GN.n7 GN.t10 32.5898
R2371 GN.n8 GN.t11 32.5898
R2372 GN.n9 GN.t12 32.5898
R2373 GN.n10 GN.t13 32.5898
R2374 GN.n11 GN.t14 32.5898
R2375 GN.n12 GN.t15 32.5898
R2376 GN.n13 GN.t16 32.5898
R2377 GN.n14 GN.t17 32.5898
R2378 GN.n15 GN.t18 32.5898
R2379 GN.n16 GN.t19 32.5898
R2380 GN.n17 GN.t20 32.5898
R2381 GN.n18 GN.t21 32.5898
R2382 GN.n19 GN.t22 32.5898
R2383 GN.n20 GN.t23 32.5898
R2384 GN.n21 GN.t24 32.5898
R2385 GN.n22 GN.t25 32.5898
R2386 GN.n23 GN.t26 32.5898
R2387 GN.n24 GN.t27 32.5898
R2388 GN.n25 GN.t28 32.5898
R2389 GN.n26 GN.t29 32.5898
R2390 GN.n27 GN.t30 32.5898
R2391 GN.n28 GN.t31 32.5898
R2392 GN.n29 GN.t32 32.5898
R2393 GN.n30 GN.t33 32.5898
R2394 GN.n31 GN.t34 32.5898
R2395 GN.n32 GN.t35 32.5898
R2396 GN.n33 GN.t36 32.5898
R2397 GN.n34 GN.t37 32.5898
R2398 GN.n35 GN.t38 32.5898
R2399 GN.n36 GN.t39 32.5898
R2400 GN.n37 GN.t40 32.5898
R2401 GN.n38 GN.t41 32.5898
R2402 GN.n38 GN.n37 11.6805
R2403 GN.n37 GN.n36 11.6805
R2404 GN.n36 GN.n35 11.6805
R2405 GN.n35 GN.n34 11.6805
R2406 GN.n34 GN.n33 11.6805
R2407 GN.n33 GN.n32 11.6805
R2408 GN.n32 GN.n31 11.6805
R2409 GN.n31 GN.n30 11.6805
R2410 GN.n30 GN.n29 11.6805
R2411 GN.n29 GN.n28 11.6805
R2412 GN.n28 GN.n27 11.6805
R2413 GN.n27 GN.n26 11.6805
R2414 GN.n26 GN.n25 11.6805
R2415 GN.n25 GN.n24 11.6805
R2416 GN.n24 GN.n23 11.6805
R2417 GN.n23 GN.n22 11.6805
R2418 GN.n22 GN.n21 11.6805
R2419 GN.n21 GN.n20 11.6805
R2420 GN.n20 GN.n19 11.6805
R2421 GN.n19 GN.n18 11.6805
R2422 GN.n18 GN.n17 11.6805
R2423 GN.n17 GN.n16 11.6805
R2424 GN.n16 GN.n15 11.6805
R2425 GN.n15 GN.n14 11.6805
R2426 GN.n14 GN.n13 11.6805
R2427 GN.n13 GN.n12 11.6805
R2428 GN.n12 GN.n11 11.6805
R2429 GN.n11 GN.n10 11.6805
R2430 GN.n10 GN.n9 11.6805
R2431 GN.n9 GN.n8 11.6805
R2432 GN.n8 GN.n7 11.6805
R2433 GN.n7 GN.n6 11.6805
R2434 GN.n6 GN.n5 11.6805
R2435 GN.n5 GN.n4 11.6805
R2436 GN.n4 GN.n3 11.6805
R2437 GN.n3 GN.n2 11.6805
R2438 GN.n2 GN.n1 11.6805
R2439 GN.n1 GN.n0 11.6805
R2440 GN.n39 GN.t1 5.15205
R2441 GN.n39 GN.t0 2.69247
R2442 GN GN.n40 0.0262143
R2443 GP.n0 GP.t2 88.5912
R2444 GP.n0 GP.t3 76.9112
R2445 GP.n1 GP.t4 76.9112
R2446 GP.n2 GP.t5 76.9112
R2447 GP.n3 GP.t6 76.9112
R2448 GP.n4 GP.t7 76.9112
R2449 GP.n5 GP.t8 76.9112
R2450 GP.n6 GP.t9 76.9112
R2451 GP.n7 GP.t10 76.9112
R2452 GP.n8 GP.t11 76.9112
R2453 GP.n9 GP.t12 76.9112
R2454 GP.n10 GP.t13 76.9112
R2455 GP.n11 GP.t14 76.9112
R2456 GP.n12 GP.t15 76.9112
R2457 GP.n13 GP.t16 76.9112
R2458 GP.n14 GP.t17 76.9112
R2459 GP.n15 GP.t18 76.9112
R2460 GP.n16 GP.t19 76.9112
R2461 GP.n17 GP.t20 76.9112
R2462 GP.n18 GP.t21 76.9112
R2463 GP.n19 GP.t22 76.9112
R2464 GP.n20 GP.t23 76.9112
R2465 GP.n21 GP.t24 76.9112
R2466 GP.n22 GP.t25 76.9112
R2467 GP.n23 GP.t26 76.9112
R2468 GP.n24 GP.t27 76.9112
R2469 GP.n25 GP.t28 76.9112
R2470 GP.n26 GP.t29 76.9112
R2471 GP.n27 GP.t30 76.9112
R2472 GP.n28 GP.t31 76.9112
R2473 GP.n29 GP.t32 76.9112
R2474 GP.n30 GP.t33 76.9112
R2475 GP.n31 GP.t34 76.9112
R2476 GP.n32 GP.t35 76.9112
R2477 GP.n33 GP.t36 76.9112
R2478 GP.n34 GP.t37 76.9112
R2479 GP.n35 GP.t38 76.9112
R2480 GP.n36 GP.t39 76.9112
R2481 GP.n37 GP.t40 76.9112
R2482 GP.n38 GP.t41 76.9112
R2483 GP.n40 GP.n39 41.6287
R2484 GP.n40 GP.n38 38.2238
R2485 GP.n38 GP.n37 11.6805
R2486 GP.n37 GP.n36 11.6805
R2487 GP.n36 GP.n35 11.6805
R2488 GP.n35 GP.n34 11.6805
R2489 GP.n34 GP.n33 11.6805
R2490 GP.n33 GP.n32 11.6805
R2491 GP.n32 GP.n31 11.6805
R2492 GP.n31 GP.n30 11.6805
R2493 GP.n30 GP.n29 11.6805
R2494 GP.n29 GP.n28 11.6805
R2495 GP.n28 GP.n27 11.6805
R2496 GP.n27 GP.n26 11.6805
R2497 GP.n26 GP.n25 11.6805
R2498 GP.n25 GP.n24 11.6805
R2499 GP.n24 GP.n23 11.6805
R2500 GP.n23 GP.n22 11.6805
R2501 GP.n22 GP.n21 11.6805
R2502 GP.n21 GP.n20 11.6805
R2503 GP.n20 GP.n19 11.6805
R2504 GP.n19 GP.n18 11.6805
R2505 GP.n18 GP.n17 11.6805
R2506 GP.n17 GP.n16 11.6805
R2507 GP.n16 GP.n15 11.6805
R2508 GP.n15 GP.n14 11.6805
R2509 GP.n14 GP.n13 11.6805
R2510 GP.n13 GP.n12 11.6805
R2511 GP.n12 GP.n11 11.6805
R2512 GP.n11 GP.n10 11.6805
R2513 GP.n10 GP.n9 11.6805
R2514 GP.n9 GP.n8 11.6805
R2515 GP.n8 GP.n7 11.6805
R2516 GP.n7 GP.n6 11.6805
R2517 GP.n6 GP.n5 11.6805
R2518 GP.n5 GP.n4 11.6805
R2519 GP.n4 GP.n3 11.6805
R2520 GP.n3 GP.n2 11.6805
R2521 GP.n2 GP.n1 11.6805
R2522 GP.n1 GP.n0 11.6805
R2523 GP.n39 GP.t0 5.15205
R2524 GP.n39 GP.t1 2.69247
R2525 GP GP.n40 0.0262143
R2526 PU_OK.t1 PU_OK.t0 119.407
R2527 PU_OK PU_OK.t1 52.6952
R2528 OE_N.t1 OE_N.t0 96.4648
R2529 OE_N OE_N.t1 53.144
R2530 OUT.t3 OUT.t1 96.4648
R2531 OUT.t2 OUT.t0 96.4648
R2532 OUT.n0 OUT.t2 47.237
R2533 OUT.n0 OUT.t3 40.559
R2534 OUT OUT.n0 12.8255
R2535 VDDIO VDDIO.t94 526.747
R2536 VDDIO VDDIO.t100 521.779
R2537 VDDIO.n42 VDDIO.t8 395.611
R2538 VDDIO.n43 VDDIO.t6 395.503
R2539 VDDIO.n45 VDDIO.t4 395.503
R2540 VDDIO.n47 VDDIO.t108 395.503
R2541 VDDIO.n41 VDDIO.t2 395.503
R2542 VDDIO.n39 VDDIO.t13 395.503
R2543 VDDIO.n38 VDDIO.t11 395.503
R2544 VDDIO.n36 VDDIO.t102 395.503
R2545 VDDIO.n34 VDDIO.t104 395.503
R2546 VDDIO.n32 VDDIO.t0 395.503
R2547 VDDIO.n30 VDDIO.t10 395.503
R2548 VDDIO.n29 VDDIO.t106 395.503
R2549 VDDIO.n27 VDDIO.t98 395.503
R2550 VDDIO.n66 VDDIO.t96 232.214
R2551 VDDIO.n0 VDDIO.t14 192.674
R2552 VDDIO.t14 VDDIO.t16 136.519
R2553 VDDIO.t16 VDDIO.t22 136.519
R2554 VDDIO.t22 VDDIO.t24 136.519
R2555 VDDIO.t24 VDDIO.t20 136.519
R2556 VDDIO.t20 VDDIO.t18 136.519
R2557 VDDIO.t18 VDDIO.t26 136.519
R2558 VDDIO.t26 VDDIO.t28 136.519
R2559 VDDIO.t28 VDDIO.t30 136.519
R2560 VDDIO.t30 VDDIO.t36 136.519
R2561 VDDIO.t36 VDDIO.t38 136.519
R2562 VDDIO.t38 VDDIO.t34 136.519
R2563 VDDIO.t34 VDDIO.t32 136.519
R2564 VDDIO.t32 VDDIO.t40 136.519
R2565 VDDIO.t40 VDDIO.t42 136.519
R2566 VDDIO.t42 VDDIO.t44 136.519
R2567 VDDIO.t44 VDDIO.t48 136.519
R2568 VDDIO.t48 VDDIO.t52 136.519
R2569 VDDIO.t52 VDDIO.t54 136.519
R2570 VDDIO.t54 VDDIO.t56 136.519
R2571 VDDIO.t56 VDDIO.t58 136.519
R2572 VDDIO.t58 VDDIO.t60 136.519
R2573 VDDIO.t60 VDDIO.t50 136.519
R2574 VDDIO.t50 VDDIO.t62 136.519
R2575 VDDIO.t62 VDDIO.t64 136.519
R2576 VDDIO.t64 VDDIO.t66 136.519
R2577 VDDIO.t66 VDDIO.t72 136.519
R2578 VDDIO.t72 VDDIO.t70 136.519
R2579 VDDIO.t70 VDDIO.t68 136.519
R2580 VDDIO.t68 VDDIO.t46 136.519
R2581 VDDIO.t46 VDDIO.t76 136.519
R2582 VDDIO.t76 VDDIO.t78 136.519
R2583 VDDIO.t78 VDDIO.t80 136.519
R2584 VDDIO.t80 VDDIO.t86 136.519
R2585 VDDIO.t86 VDDIO.t84 136.519
R2586 VDDIO.t84 VDDIO.t82 136.519
R2587 VDDIO.t82 VDDIO.t74 136.519
R2588 VDDIO.t74 VDDIO.t88 136.519
R2589 VDDIO.t88 VDDIO.t90 136.519
R2590 VDDIO.t90 VDDIO.t92 136.519
R2591 VDDIO.n50 VDDIO.n49 14.0765
R2592 VDDIO.n64 VDDIO.n63 10.7074
R2593 VDDIO.n65 VDDIO.n64 8.4605
R2594 VDDIO.n20 VDDIO.t93 7.27651
R2595 VDDIO.n20 VDDIO.n19 6.55251
R2596 VDDIO.n21 VDDIO.n18 6.55251
R2597 VDDIO.n22 VDDIO.n17 6.55251
R2598 VDDIO.n23 VDDIO.n16 6.55251
R2599 VDDIO.n24 VDDIO.n15 6.55251
R2600 VDDIO.n25 VDDIO.n14 6.55251
R2601 VDDIO.n26 VDDIO.n13 6.55251
R2602 VDDIO.n51 VDDIO.n12 6.55251
R2603 VDDIO.n52 VDDIO.n11 6.55251
R2604 VDDIO.n53 VDDIO.n10 6.55251
R2605 VDDIO.n54 VDDIO.n9 6.55251
R2606 VDDIO.n55 VDDIO.n8 6.55251
R2607 VDDIO.n56 VDDIO.n7 6.55251
R2608 VDDIO.n57 VDDIO.n6 6.55251
R2609 VDDIO.n58 VDDIO.n5 6.55251
R2610 VDDIO.n59 VDDIO.n4 6.55251
R2611 VDDIO.n60 VDDIO.n3 6.55251
R2612 VDDIO.n61 VDDIO.n2 6.55251
R2613 VDDIO.n62 VDDIO.n1 6.55251
R2614 VDDIO.n63 VDDIO.n0 5.80076
R2615 VDDIO VDDIO.n66 5.58476
R2616 VDDIO.n64 VDDIO 4.9355
R2617 VDDIO.n65 VDDIO 4.9355
R2618 VDDIO.n27 VDDIO.t99 3.0835
R2619 VDDIO.n42 VDDIO.t9 2.9755
R2620 VDDIO.n44 VDDIO.t7 2.9755
R2621 VDDIO.n46 VDDIO.t5 2.9755
R2622 VDDIO.n48 VDDIO.t109 2.9755
R2623 VDDIO.n40 VDDIO.t3 2.9755
R2624 VDDIO.n37 VDDIO.t12 2.9755
R2625 VDDIO.n35 VDDIO.t103 2.9755
R2626 VDDIO.n33 VDDIO.t105 2.9755
R2627 VDDIO.n31 VDDIO.t1 2.9755
R2628 VDDIO.n28 VDDIO.t107 2.9755
R2629 VDDIO.n66 VDDIO.t97 1.21208
R2630 VDDIO.n0 VDDIO.t15 1.1095
R2631 VDDIO VDDIO.n65 1.0805
R2632 VDDIO.n39 VDDIO.n38 0.5855
R2633 VDDIO.n30 VDDIO.n29 0.5855
R2634 VDDIO.n43 VDDIO.n42 0.4925
R2635 VDDIO.n45 VDDIO.n44 0.4925
R2636 VDDIO.n37 VDDIO.n36 0.4925
R2637 VDDIO.n35 VDDIO.n34 0.4925
R2638 VDDIO.n33 VDDIO.n32 0.4925
R2639 VDDIO.n28 VDDIO.n27 0.4925
R2640 VDDIO.n49 VDDIO.n41 0.4325
R2641 VDDIO.n19 VDDIO.t89 0.3645
R2642 VDDIO.n19 VDDIO.t91 0.3645
R2643 VDDIO.n18 VDDIO.t83 0.3645
R2644 VDDIO.n18 VDDIO.t75 0.3645
R2645 VDDIO.n17 VDDIO.t87 0.3645
R2646 VDDIO.n17 VDDIO.t85 0.3645
R2647 VDDIO.n16 VDDIO.t79 0.3645
R2648 VDDIO.n16 VDDIO.t81 0.3645
R2649 VDDIO.n15 VDDIO.t47 0.3645
R2650 VDDIO.n15 VDDIO.t77 0.3645
R2651 VDDIO.n14 VDDIO.t71 0.3645
R2652 VDDIO.n14 VDDIO.t69 0.3645
R2653 VDDIO.n13 VDDIO.t67 0.3645
R2654 VDDIO.n13 VDDIO.t73 0.3645
R2655 VDDIO.n12 VDDIO.t63 0.3645
R2656 VDDIO.n12 VDDIO.t65 0.3645
R2657 VDDIO.n11 VDDIO.t61 0.3645
R2658 VDDIO.n11 VDDIO.t51 0.3645
R2659 VDDIO.n10 VDDIO.t57 0.3645
R2660 VDDIO.n10 VDDIO.t59 0.3645
R2661 VDDIO.n9 VDDIO.t53 0.3645
R2662 VDDIO.n9 VDDIO.t55 0.3645
R2663 VDDIO.n8 VDDIO.t45 0.3645
R2664 VDDIO.n8 VDDIO.t49 0.3645
R2665 VDDIO.n7 VDDIO.t41 0.3645
R2666 VDDIO.n7 VDDIO.t43 0.3645
R2667 VDDIO.n6 VDDIO.t35 0.3645
R2668 VDDIO.n6 VDDIO.t33 0.3645
R2669 VDDIO.n5 VDDIO.t37 0.3645
R2670 VDDIO.n5 VDDIO.t39 0.3645
R2671 VDDIO.n4 VDDIO.t29 0.3645
R2672 VDDIO.n4 VDDIO.t31 0.3645
R2673 VDDIO.n3 VDDIO.t19 0.3645
R2674 VDDIO.n3 VDDIO.t27 0.3645
R2675 VDDIO.n2 VDDIO.t25 0.3645
R2676 VDDIO.n2 VDDIO.t21 0.3645
R2677 VDDIO.n1 VDDIO.t17 0.3645
R2678 VDDIO.n1 VDDIO.t23 0.3645
R2679 VDDIO.n62 VDDIO.n61 0.3605
R2680 VDDIO.n61 VDDIO.n60 0.3605
R2681 VDDIO.n60 VDDIO.n59 0.3605
R2682 VDDIO.n59 VDDIO.n58 0.3605
R2683 VDDIO.n58 VDDIO.n57 0.3605
R2684 VDDIO.n57 VDDIO.n56 0.3605
R2685 VDDIO.n56 VDDIO.n55 0.3605
R2686 VDDIO.n55 VDDIO.n54 0.3605
R2687 VDDIO.n54 VDDIO.n53 0.3605
R2688 VDDIO.n53 VDDIO.n52 0.3605
R2689 VDDIO.n52 VDDIO.n51 0.3605
R2690 VDDIO.n26 VDDIO.n25 0.3605
R2691 VDDIO.n25 VDDIO.n24 0.3605
R2692 VDDIO.n24 VDDIO.n23 0.3605
R2693 VDDIO.n23 VDDIO.n22 0.3605
R2694 VDDIO.n22 VDDIO.n21 0.3605
R2695 VDDIO.n21 VDDIO.n20 0.3605
R2696 VDDIO.n47 VDDIO.n46 0.3575
R2697 VDDIO.n40 VDDIO.n39 0.3575
R2698 VDDIO.n31 VDDIO.n30 0.3575
R2699 VDDIO VDDIO.n62 0.345535
R2700 VDDIO.n50 VDDIO.n26 0.221
R2701 VDDIO.n51 VDDIO.n50 0.14
R2702 VDDIO.n44 VDDIO.n43 0.1085
R2703 VDDIO.n46 VDDIO.n45 0.1085
R2704 VDDIO.n48 VDDIO.n47 0.1085
R2705 VDDIO.n41 VDDIO.n40 0.1085
R2706 VDDIO.n38 VDDIO.n37 0.1085
R2707 VDDIO.n36 VDDIO.n35 0.1085
R2708 VDDIO.n34 VDDIO.n33 0.1085
R2709 VDDIO.n32 VDDIO.n31 0.1085
R2710 VDDIO.n29 VDDIO.n28 0.1085
R2711 VDDIO.n49 VDDIO.n48 0.0455
R2712 VDDIO.n63 VDDIO 0.00259302
R2713 VSSIO.n198 VSSIO.n23 23902.5
R2714 VSSIO.n68 VSSIO.n66 14754
R2715 VSSIO.n122 VSSIO.n29 14754
R2716 VSSIO.n124 VSSIO.n27 14754
R2717 VSSIO.n156 VSSIO.n23 7184.56
R2718 VSSIO.n100 VSSIO.n65 6500
R2719 VSSIO.n121 VSSIO.n30 6500
R2720 VSSIO.n123 VSSIO.n28 6500
R2721 VSSIO.n126 VSSIO.n25 6075.16
R2722 VSSIO.n119 VSSIO.n32 6075.16
R2723 VSSIO.n103 VSSIO.n64 6075.16
R2724 VSSIO.n71 VSSIO.n69 6075.16
R2725 VSSIO.n125 VSSIO.n26 6075.16
R2726 VSSIO.n120 VSSIO.n31 5939.47
R2727 VSSIO.n127 VSSIO.n126 5843.71
R2728 VSSIO.n197 VSSIO.n127 4905.69
R2729 VSSIO.t220 VSSIO.n195 4286.02
R2730 VSSIO.t226 VSSIO.n63 2878.83
R2731 VSSIO.n126 VSSIO.n125 2863.44
R2732 VSSIO.n121 VSSIO.n120 2747.36
R2733 VSSIO.n125 VSSIO.n124 2541.3
R2734 VSSIO.n124 VSSIO.n123 2505.51
R2735 VSSIO.n123 VSSIO.n122 2505.51
R2736 VSSIO.n122 VSSIO.n121 2505.51
R2737 VSSIO.n198 VSSIO.n197 2054.5
R2738 VSSIO.n196 VSSIO.t220 1721.23
R2739 VSSIO.n168 VSSIO.t118 1698.67
R2740 VSSIO.n127 VSSIO.n24 1499.81
R2741 VSSIO.n120 VSSIO.n119 1323.82
R2742 VSSIO.n198 VSSIO.t222 1089.29
R2743 VSSIO.n119 VSSIO.n118 839.062
R2744 VSSIO.n199 VSSIO.n198 822.636
R2745 VSSIO.n200 VSSIO.n199 700.774
R2746 VSSIO.n196 VSSIO.t218 439.973
R2747 VSSIO.n25 VSSIO.t128 374.108
R2748 VSSIO.t122 VSSIO.n26 374.108
R2749 VSSIO.t228 VSSIO.n32 374.108
R2750 VSSIO.t132 VSSIO.n71 374.108
R2751 VSSIO.n103 VSSIO.t224 374.108
R2752 VSSIO.t230 VSSIO.n31 373.075
R2753 VSSIO.n82 VSSIO.n28 372.002
R2754 VSSIO.t124 VSSIO.n30 363.57
R2755 VSSIO.n100 VSSIO.t130 363.57
R2756 VSSIO.n118 VSSIO.t140 350
R2757 VSSIO.n84 VSSIO.n27 287.695
R2758 VSSIO.t134 VSSIO.n29 279.264
R2759 VSSIO.t126 VSSIO.n66 279.264
R2760 VSSIO.t142 VSSIO.t138 250
R2761 VSSIO.t138 VSSIO.t146 250
R2762 VSSIO.t146 VSSIO.t148 250
R2763 VSSIO.t150 VSSIO.t154 250
R2764 VSSIO.t154 VSSIO.t152 250
R2765 VSSIO.t152 VSSIO.t156 250
R2766 VSSIO.t156 VSSIO.t144 250
R2767 VSSIO.t158 VSSIO.t160 250
R2768 VSSIO.t160 VSSIO.t162 250
R2769 VSSIO.t162 VSSIO.t164 250
R2770 VSSIO.t166 VSSIO.t168 250
R2771 VSSIO.t168 VSSIO.t170 250
R2772 VSSIO.t170 VSSIO.t176 250
R2773 VSSIO.t176 VSSIO.t180 250
R2774 VSSIO.t180 VSSIO.t178 250
R2775 VSSIO.t178 VSSIO.t174 250
R2776 VSSIO.t174 VSSIO.t182 250
R2777 VSSIO.t182 VSSIO.t184 250
R2778 VSSIO.t198 VSSIO.t186 250
R2779 VSSIO.t194 VSSIO.t198 250
R2780 VSSIO.t190 VSSIO.t194 250
R2781 VSSIO.t200 VSSIO.t190 250
R2782 VSSIO.t196 VSSIO.t200 250
R2783 VSSIO.t192 VSSIO.t196 250
R2784 VSSIO.t188 VSSIO.t192 250
R2785 VSSIO.t172 VSSIO.t188 250
R2786 VSSIO.t202 VSSIO.t172 250
R2787 VSSIO.t206 VSSIO.t202 250
R2788 VSSIO.t208 VSSIO.t206 250
R2789 VSSIO.t212 VSSIO.t208 250
R2790 VSSIO.t210 VSSIO.t212 250
R2791 VSSIO.t214 VSSIO.t204 250
R2792 VSSIO.t204 VSSIO.t216 250
R2793 VSSIO.t164 VSSIO.n64 248.439
R2794 VSSIO.t128 VSSIO.n24 236.058
R2795 VSSIO.n85 VSSIO.t122 236.058
R2796 VSSIO.n84 VSSIO.t121 236.058
R2797 VSSIO.n82 VSSIO.t136 236.058
R2798 VSSIO.n80 VSSIO.t134 236.058
R2799 VSSIO.n78 VSSIO.t124 236.058
R2800 VSSIO.n76 VSSIO.t230 236.058
R2801 VSSIO.n74 VSSIO.t228 236.058
R2802 VSSIO.n72 VSSIO.t132 236.058
R2803 VSSIO.n70 VSSIO.t126 236.058
R2804 VSSIO.t130 VSSIO.n99 236.058
R2805 VSSIO.t224 VSSIO.n102 236.058
R2806 VSSIO.n104 VSSIO.t226 236.058
R2807 VSSIO.n65 VSSIO.t158 235.939
R2808 VSSIO.n85 VSSIO.n25 232.897
R2809 VSSIO.n72 VSSIO.n32 232.897
R2810 VSSIO.n71 VSSIO.n70 232.897
R2811 VSSIO.n104 VSSIO.n103 232.897
R2812 VSSIO.n74 VSSIO.n31 231.821
R2813 VSSIO.t121 VSSIO.n26 224.465
R2814 VSSIO.n199 VSSIO.t184 223.439
R2815 VSSIO.n80 VSSIO.n28 222.357
R2816 VSSIO.n76 VSSIO.n30 222.357
R2817 VSSIO.n102 VSSIO.n100 222.357
R2818 VSSIO.n63 VSSIO.t210 195.312
R2819 VSSIO.n69 VSSIO.t142 189.062
R2820 VSSIO.t148 VSSIO.n68 170.312
R2821 VSSIO.n156 VSSIO.t58 170.024
R2822 VSSIO.n78 VSSIO.n29 138.052
R2823 VSSIO.n99 VSSIO.n66 138.052
R2824 VSSIO.t136 VSSIO.n27 129.621
R2825 VSSIO.n157 VSSIO.n156 128.917
R2826 VSSIO.n157 VSSIO.t61 121.334
R2827 VSSIO.n168 VSSIO.t222 121.334
R2828 VSSIO.n200 VSSIO.t120 101.365
R2829 VSSIO.t4 VSSIO.t1 97.8552
R2830 VSSIO.t7 VSSIO.t4 97.8552
R2831 VSSIO.t10 VSSIO.t7 97.8552
R2832 VSSIO.t13 VSSIO.t10 97.8552
R2833 VSSIO.t16 VSSIO.t13 97.8552
R2834 VSSIO.t19 VSSIO.t16 97.8552
R2835 VSSIO.t22 VSSIO.t19 97.8552
R2836 VSSIO.t25 VSSIO.t22 97.8552
R2837 VSSIO.t28 VSSIO.t25 97.8552
R2838 VSSIO.t31 VSSIO.t28 97.8552
R2839 VSSIO.t34 VSSIO.t31 97.8552
R2840 VSSIO.t37 VSSIO.t34 97.8552
R2841 VSSIO.t40 VSSIO.t37 97.8552
R2842 VSSIO.t43 VSSIO.t40 97.8552
R2843 VSSIO.t46 VSSIO.t43 97.8552
R2844 VSSIO.t49 VSSIO.t46 97.8552
R2845 VSSIO.t52 VSSIO.t49 97.8552
R2846 VSSIO.t55 VSSIO.t52 97.8552
R2847 VSSIO.t58 VSSIO.t55 97.8552
R2848 VSSIO.t61 VSSIO.t64 86.6672
R2849 VSSIO.t64 VSSIO.t67 86.6672
R2850 VSSIO.t67 VSSIO.t70 86.6672
R2851 VSSIO.t70 VSSIO.t73 86.6672
R2852 VSSIO.t73 VSSIO.t76 86.6672
R2853 VSSIO.t76 VSSIO.t79 86.6672
R2854 VSSIO.t79 VSSIO.t82 86.6672
R2855 VSSIO.t82 VSSIO.t85 86.6672
R2856 VSSIO.t85 VSSIO.t88 86.6672
R2857 VSSIO.t88 VSSIO.t91 86.6672
R2858 VSSIO.t91 VSSIO.t94 86.6672
R2859 VSSIO.t94 VSSIO.t97 86.6672
R2860 VSSIO.t97 VSSIO.t100 86.6672
R2861 VSSIO.t100 VSSIO.t103 86.6672
R2862 VSSIO.t103 VSSIO.t106 86.6672
R2863 VSSIO.t106 VSSIO.t109 86.6672
R2864 VSSIO.t109 VSSIO.t112 86.6672
R2865 VSSIO.t118 VSSIO.t115 86.6672
R2866 VSSIO.n195 VSSIO.n194 79.9969
R2867 VSSIO.n68 VSSIO.t150 79.688
R2868 VSSIO.n69 VSSIO.t140 60.938
R2869 VSSIO.n195 VSSIO.t1 59.9365
R2870 VSSIO.t112 VSSIO.n23 55.7922
R2871 VSSIO.n63 VSSIO.t214 54.688
R2872 VSSIO.n137 VSSIO.t117 44.2698
R2873 VSSIO.n2 VSSIO.t57 44.2698
R2874 VSSIO.n21 VSSIO.n20 43.0442
R2875 VSSIO.n182 VSSIO.n155 42.7878
R2876 VSSIO.n197 VSSIO.n196 33.4523
R2877 VSSIO.n202 VSSIO.n201 33.233
R2878 VSSIO.n137 VSSIO.t114 32.5898
R2879 VSSIO.n138 VSSIO.t111 32.5898
R2880 VSSIO.n139 VSSIO.t108 32.5898
R2881 VSSIO.n140 VSSIO.t105 32.5898
R2882 VSSIO.n141 VSSIO.t102 32.5898
R2883 VSSIO.n142 VSSIO.t99 32.5898
R2884 VSSIO.n143 VSSIO.t96 32.5898
R2885 VSSIO.n144 VSSIO.t93 32.5898
R2886 VSSIO.n145 VSSIO.t90 32.5898
R2887 VSSIO.n146 VSSIO.t87 32.5898
R2888 VSSIO.n147 VSSIO.t84 32.5898
R2889 VSSIO.n148 VSSIO.t81 32.5898
R2890 VSSIO.n149 VSSIO.t78 32.5898
R2891 VSSIO.n150 VSSIO.t75 32.5898
R2892 VSSIO.n151 VSSIO.t72 32.5898
R2893 VSSIO.n152 VSSIO.t69 32.5898
R2894 VSSIO.n153 VSSIO.t66 32.5898
R2895 VSSIO.n154 VSSIO.t63 32.5898
R2896 VSSIO.n155 VSSIO.t60 32.5898
R2897 VSSIO.n2 VSSIO.t54 32.5898
R2898 VSSIO.n3 VSSIO.t51 32.5898
R2899 VSSIO.n4 VSSIO.t48 32.5898
R2900 VSSIO.n5 VSSIO.t45 32.5898
R2901 VSSIO.n6 VSSIO.t42 32.5898
R2902 VSSIO.n7 VSSIO.t39 32.5898
R2903 VSSIO.n8 VSSIO.t36 32.5898
R2904 VSSIO.n9 VSSIO.t33 32.5898
R2905 VSSIO.n10 VSSIO.t30 32.5898
R2906 VSSIO.n11 VSSIO.t27 32.5898
R2907 VSSIO.n12 VSSIO.t24 32.5898
R2908 VSSIO.n13 VSSIO.t21 32.5898
R2909 VSSIO.n14 VSSIO.t18 32.5898
R2910 VSSIO.n15 VSSIO.t15 32.5898
R2911 VSSIO.n16 VSSIO.t12 32.5898
R2912 VSSIO.n17 VSSIO.t9 32.5898
R2913 VSSIO.n18 VSSIO.t6 32.5898
R2914 VSSIO.n19 VSSIO.t3 32.5898
R2915 VSSIO.n20 VSSIO.t0 32.5898
R2916 VSSIO.t115 VSSIO.n23 30.8755
R2917 VSSIO.n199 VSSIO.t186 26.563
R2918 VSSIO.n107 VSSIO.n106 16.8827
R2919 VSSIO.t144 VSSIO.n65 14.063
R2920 VSSIO.n201 VSSIO.n22 13.595
R2921 VSSIO.n201 VSSIO 12.4655
R2922 VSSIO.n155 VSSIO.n154 11.6805
R2923 VSSIO.n154 VSSIO.n153 11.6805
R2924 VSSIO.n153 VSSIO.n152 11.6805
R2925 VSSIO.n152 VSSIO.n151 11.6805
R2926 VSSIO.n151 VSSIO.n150 11.6805
R2927 VSSIO.n150 VSSIO.n149 11.6805
R2928 VSSIO.n149 VSSIO.n148 11.6805
R2929 VSSIO.n148 VSSIO.n147 11.6805
R2930 VSSIO.n147 VSSIO.n146 11.6805
R2931 VSSIO.n146 VSSIO.n145 11.6805
R2932 VSSIO.n145 VSSIO.n144 11.6805
R2933 VSSIO.n144 VSSIO.n143 11.6805
R2934 VSSIO.n143 VSSIO.n142 11.6805
R2935 VSSIO.n142 VSSIO.n141 11.6805
R2936 VSSIO.n141 VSSIO.n140 11.6805
R2937 VSSIO.n140 VSSIO.n139 11.6805
R2938 VSSIO.n139 VSSIO.n138 11.6805
R2939 VSSIO.n138 VSSIO.n137 11.6805
R2940 VSSIO.n20 VSSIO.n19 11.6805
R2941 VSSIO.n19 VSSIO.n18 11.6805
R2942 VSSIO.n18 VSSIO.n17 11.6805
R2943 VSSIO.n17 VSSIO.n16 11.6805
R2944 VSSIO.n16 VSSIO.n15 11.6805
R2945 VSSIO.n15 VSSIO.n14 11.6805
R2946 VSSIO.n14 VSSIO.n13 11.6805
R2947 VSSIO.n13 VSSIO.n12 11.6805
R2948 VSSIO.n12 VSSIO.n11 11.6805
R2949 VSSIO.n11 VSSIO.n10 11.6805
R2950 VSSIO.n10 VSSIO.n9 11.6805
R2951 VSSIO.n9 VSSIO.n8 11.6805
R2952 VSSIO.n8 VSSIO.n7 11.6805
R2953 VSSIO.n7 VSSIO.n6 11.6805
R2954 VSSIO.n6 VSSIO.n5 11.6805
R2955 VSSIO.n5 VSSIO.n4 11.6805
R2956 VSSIO.n4 VSSIO.n3 11.6805
R2957 VSSIO.n3 VSSIO.n2 11.6805
R2958 VSSIO.n1 VSSIO 9.2345
R2959 VSSIO.n0 VSSIO 8.0555
R2960 VSSIO.n22 VSSIO.t217 7.3895
R2961 VSSIO.n183 VSSIO.t59 7.277
R2962 VSSIO.n171 VSSIO.t119 7.277
R2963 VSSIO.n52 VSSIO.n51 6.53225
R2964 VSSIO.n53 VSSIO.n50 6.53225
R2965 VSSIO.n54 VSSIO.n49 6.53225
R2966 VSSIO.n55 VSSIO.n48 6.53225
R2967 VSSIO.n56 VSSIO.n47 6.53225
R2968 VSSIO.n57 VSSIO.n46 6.53225
R2969 VSSIO.n58 VSSIO.n45 6.53225
R2970 VSSIO.n59 VSSIO.n44 6.53225
R2971 VSSIO.n60 VSSIO.n43 6.53225
R2972 VSSIO.n61 VSSIO.n42 6.53225
R2973 VSSIO.n108 VSSIO.n41 6.53225
R2974 VSSIO.n109 VSSIO.n40 6.53225
R2975 VSSIO.n110 VSSIO.n39 6.53225
R2976 VSSIO.n111 VSSIO.n38 6.53225
R2977 VSSIO.n112 VSSIO.n37 6.53225
R2978 VSSIO.n113 VSSIO.n36 6.53225
R2979 VSSIO.n114 VSSIO.n35 6.53225
R2980 VSSIO.n115 VSSIO.n34 6.53225
R2981 VSSIO.n116 VSSIO.n33 6.53225
R2982 VSSIO.n184 VSSIO.n136 6.458
R2983 VSSIO.n185 VSSIO.n135 6.458
R2984 VSSIO.n186 VSSIO.n134 6.458
R2985 VSSIO.n187 VSSIO.n133 6.458
R2986 VSSIO.n188 VSSIO.n132 6.458
R2987 VSSIO.n189 VSSIO.n131 6.458
R2988 VSSIO.n190 VSSIO.n130 6.458
R2989 VSSIO.n191 VSSIO.n129 6.458
R2990 VSSIO.n192 VSSIO.n128 6.458
R2991 VSSIO.n172 VSSIO.n167 6.458
R2992 VSSIO.n173 VSSIO.n166 6.458
R2993 VSSIO.n174 VSSIO.n165 6.458
R2994 VSSIO.n175 VSSIO.n164 6.458
R2995 VSSIO.n176 VSSIO.n163 6.458
R2996 VSSIO.n177 VSSIO.n162 6.458
R2997 VSSIO.n178 VSSIO.n161 6.458
R2998 VSSIO.n179 VSSIO.n160 6.458
R2999 VSSIO.n180 VSSIO.n159 6.458
R3000 VSSIO.n89 VSSIO.n84 5.66277
R3001 VSSIO.n0 VSSIO 5.5355
R3002 VSSIO.n87 VSSIO.n24 5.2005
R3003 VSSIO.n86 VSSIO.n85 5.2005
R3004 VSSIO.n83 VSSIO.n82 5.2005
R3005 VSSIO.n81 VSSIO.n80 5.2005
R3006 VSSIO.n79 VSSIO.n78 5.2005
R3007 VSSIO.n77 VSSIO.n76 5.2005
R3008 VSSIO.n75 VSSIO.n74 5.2005
R3009 VSSIO.n73 VSSIO.n72 5.2005
R3010 VSSIO.n70 VSSIO.n67 5.2005
R3011 VSSIO.n99 VSSIO.n98 5.2005
R3012 VSSIO.n102 VSSIO.n101 5.2005
R3013 VSSIO.n105 VSSIO.n104 5.2005
R3014 VSSIO.n170 VSSIO.n169 5.1222
R3015 VSSIO.n117 VSSIO 4.9595
R3016 VSSIO.n105 VSSIO.t227 4.901
R3017 VSSIO.n101 VSSIO.t225 4.901
R3018 VSSIO.n98 VSSIO.t131 4.901
R3019 VSSIO.n67 VSSIO.t127 4.901
R3020 VSSIO.n73 VSSIO.t133 4.901
R3021 VSSIO.n75 VSSIO.t229 4.901
R3022 VSSIO.n77 VSSIO.t231 4.901
R3023 VSSIO.n79 VSSIO.t125 4.901
R3024 VSSIO.n81 VSSIO.t135 4.901
R3025 VSSIO.n83 VSSIO.t137 4.901
R3026 VSSIO.n86 VSSIO.t123 4.901
R3027 VSSIO.n87 VSSIO.t129 4.901
R3028 VSSIO.n194 VSSIO.n193 4.883
R3029 VSSIO.n181 VSSIO.n158 4.883
R3030 VSSIO.n171 VSSIO.n170 3.61654
R3031 VSSIO.n169 VSSIO.n168 2.93626
R3032 VSSIO.n158 VSSIO.n157 2.93626
R3033 VSSIO.n118 VSSIO.n117 2.93626
R3034 VSSIO.n158 VSSIO.t62 2.3945
R3035 VSSIO.n169 VSSIO.t223 2.3945
R3036 VSSIO.n117 VSSIO.t141 2.3945
R3037 VSSIO.n194 VSSIO.t2 2.3945
R3038 VSSIO.n1 VSSIO.n0 2.3405
R3039 VSSIO.n64 VSSIO.t166 1.563
R3040 VSSIO VSSIO.n1 1.4405
R3041 VSSIO.n88 VSSIO.n87 1.06277
R3042 VSSIO.n202 VSSIO.n21 0.9995
R3043 VSSIO.n136 VSSIO.t53 0.8195
R3044 VSSIO.n136 VSSIO.t56 0.8195
R3045 VSSIO.n135 VSSIO.t47 0.8195
R3046 VSSIO.n135 VSSIO.t50 0.8195
R3047 VSSIO.n134 VSSIO.t41 0.8195
R3048 VSSIO.n134 VSSIO.t44 0.8195
R3049 VSSIO.n133 VSSIO.t35 0.8195
R3050 VSSIO.n133 VSSIO.t38 0.8195
R3051 VSSIO.n132 VSSIO.t29 0.8195
R3052 VSSIO.n132 VSSIO.t32 0.8195
R3053 VSSIO.n131 VSSIO.t23 0.8195
R3054 VSSIO.n131 VSSIO.t26 0.8195
R3055 VSSIO.n130 VSSIO.t17 0.8195
R3056 VSSIO.n130 VSSIO.t20 0.8195
R3057 VSSIO.n129 VSSIO.t11 0.8195
R3058 VSSIO.n129 VSSIO.t14 0.8195
R3059 VSSIO.n128 VSSIO.t5 0.8195
R3060 VSSIO.n128 VSSIO.t8 0.8195
R3061 VSSIO.n167 VSSIO.t113 0.8195
R3062 VSSIO.n167 VSSIO.t116 0.8195
R3063 VSSIO.n166 VSSIO.t107 0.8195
R3064 VSSIO.n166 VSSIO.t110 0.8195
R3065 VSSIO.n165 VSSIO.t101 0.8195
R3066 VSSIO.n165 VSSIO.t104 0.8195
R3067 VSSIO.n164 VSSIO.t95 0.8195
R3068 VSSIO.n164 VSSIO.t98 0.8195
R3069 VSSIO.n163 VSSIO.t89 0.8195
R3070 VSSIO.n163 VSSIO.t92 0.8195
R3071 VSSIO.n162 VSSIO.t83 0.8195
R3072 VSSIO.n162 VSSIO.t86 0.8195
R3073 VSSIO.n161 VSSIO.t77 0.8195
R3074 VSSIO.n161 VSSIO.t80 0.8195
R3075 VSSIO.n160 VSSIO.t71 0.8195
R3076 VSSIO.n160 VSSIO.t74 0.8195
R3077 VSSIO.n159 VSSIO.t65 0.8195
R3078 VSSIO.n159 VSSIO.t68 0.8195
R3079 VSSIO.n51 VSSIO.t215 0.8195
R3080 VSSIO.n51 VSSIO.t205 0.8195
R3081 VSSIO.n50 VSSIO.t213 0.8195
R3082 VSSIO.n50 VSSIO.t211 0.8195
R3083 VSSIO.n49 VSSIO.t207 0.8195
R3084 VSSIO.n49 VSSIO.t209 0.8195
R3085 VSSIO.n48 VSSIO.t173 0.8195
R3086 VSSIO.n48 VSSIO.t203 0.8195
R3087 VSSIO.n47 VSSIO.t193 0.8195
R3088 VSSIO.n47 VSSIO.t189 0.8195
R3089 VSSIO.n46 VSSIO.t201 0.8195
R3090 VSSIO.n46 VSSIO.t197 0.8195
R3091 VSSIO.n45 VSSIO.t195 0.8195
R3092 VSSIO.n45 VSSIO.t191 0.8195
R3093 VSSIO.n44 VSSIO.t187 0.8195
R3094 VSSIO.n44 VSSIO.t199 0.8195
R3095 VSSIO.n43 VSSIO.t183 0.8195
R3096 VSSIO.n43 VSSIO.t185 0.8195
R3097 VSSIO.n42 VSSIO.t179 0.8195
R3098 VSSIO.n42 VSSIO.t175 0.8195
R3099 VSSIO.n41 VSSIO.t177 0.8195
R3100 VSSIO.n41 VSSIO.t181 0.8195
R3101 VSSIO.n40 VSSIO.t169 0.8195
R3102 VSSIO.n40 VSSIO.t171 0.8195
R3103 VSSIO.n39 VSSIO.t165 0.8195
R3104 VSSIO.n39 VSSIO.t167 0.8195
R3105 VSSIO.n38 VSSIO.t161 0.8195
R3106 VSSIO.n38 VSSIO.t163 0.8195
R3107 VSSIO.n37 VSSIO.t145 0.8195
R3108 VSSIO.n37 VSSIO.t159 0.8195
R3109 VSSIO.n36 VSSIO.t153 0.8195
R3110 VSSIO.n36 VSSIO.t157 0.8195
R3111 VSSIO.n35 VSSIO.t151 0.8195
R3112 VSSIO.n35 VSSIO.t155 0.8195
R3113 VSSIO.n34 VSSIO.t147 0.8195
R3114 VSSIO.n34 VSSIO.t149 0.8195
R3115 VSSIO.n33 VSSIO.t143 0.8195
R3116 VSSIO.n33 VSSIO.t139 0.8195
R3117 VSSIO.n89 VSSIO.n88 0.7625
R3118 VSSIO.n94 VSSIO.n93 0.6005
R3119 VSSIO.n95 VSSIO.n94 0.6005
R3120 VSSIO.n96 VSSIO.n95 0.6005
R3121 VSSIO.n106 VSSIO.n62 0.6005
R3122 VSSIO.n93 VSSIO.n92 0.5855
R3123 VSSIO.n97 VSSIO.n62 0.5855
R3124 VSSIO.n90 VSSIO.n89 0.4655
R3125 VSSIO.n92 VSSIO.n91 0.4655
R3126 VSSIO.n97 VSSIO.n96 0.4655
R3127 VSSIO.n106 VSSIO.n105 0.462773
R3128 VSSIO.n101 VSSIO.n62 0.462773
R3129 VSSIO.n98 VSSIO.n97 0.462773
R3130 VSSIO.n96 VSSIO.n67 0.462773
R3131 VSSIO.n95 VSSIO.n73 0.462773
R3132 VSSIO.n94 VSSIO.n75 0.462773
R3133 VSSIO.n93 VSSIO.n77 0.462773
R3134 VSSIO.n92 VSSIO.n79 0.462773
R3135 VSSIO.n91 VSSIO.n81 0.462773
R3136 VSSIO.n90 VSSIO.n83 0.462773
R3137 VSSIO.n88 VSSIO.n86 0.462773
R3138 VSSIO.n91 VSSIO.n90 0.4235
R3139 VSSIO.n116 VSSIO.n115 0.3605
R3140 VSSIO.n115 VSSIO.n114 0.3605
R3141 VSSIO.n114 VSSIO.n113 0.3605
R3142 VSSIO.n113 VSSIO.n112 0.3605
R3143 VSSIO.n112 VSSIO.n111 0.3605
R3144 VSSIO.n111 VSSIO.n110 0.3605
R3145 VSSIO.n110 VSSIO.n109 0.3605
R3146 VSSIO.n109 VSSIO.n108 0.3605
R3147 VSSIO.n61 VSSIO.n60 0.3605
R3148 VSSIO.n60 VSSIO.n59 0.3605
R3149 VSSIO.n59 VSSIO.n58 0.3605
R3150 VSSIO.n58 VSSIO.n57 0.3605
R3151 VSSIO.n57 VSSIO.n56 0.3605
R3152 VSSIO.n56 VSSIO.n55 0.3605
R3153 VSSIO.n55 VSSIO.n54 0.3605
R3154 VSSIO.n54 VSSIO.n53 0.3605
R3155 VSSIO.n53 VSSIO.n52 0.3605
R3156 VSSIO VSSIO.n116 0.35825
R3157 VSSIO.n52 VSSIO.n22 0.32225
R3158 VSSIO.n108 VSSIO.n107 0.32
R3159 VSSIO.n182 VSSIO.n181 0.232281
R3160 VSSIO VSSIO.n200 0.221777
R3161 VSSIO.n193 VSSIO.n192 0.19776
R3162 VSSIO.n192 VSSIO.n191 0.19776
R3163 VSSIO.n191 VSSIO.n190 0.19776
R3164 VSSIO.n190 VSSIO.n189 0.19776
R3165 VSSIO.n189 VSSIO.n188 0.19776
R3166 VSSIO.n188 VSSIO.n187 0.19776
R3167 VSSIO.n187 VSSIO.n186 0.19776
R3168 VSSIO.n186 VSSIO.n185 0.19776
R3169 VSSIO.n185 VSSIO.n184 0.19776
R3170 VSSIO.n184 VSSIO.n183 0.19776
R3171 VSSIO.n181 VSSIO.n180 0.19776
R3172 VSSIO.n180 VSSIO.n179 0.19776
R3173 VSSIO.n179 VSSIO.n178 0.19776
R3174 VSSIO.n178 VSSIO.n177 0.19776
R3175 VSSIO.n177 VSSIO.n176 0.19776
R3176 VSSIO.n176 VSSIO.n175 0.19776
R3177 VSSIO.n175 VSSIO.n174 0.19776
R3178 VSSIO.n174 VSSIO.n173 0.19776
R3179 VSSIO.n173 VSSIO.n172 0.19776
R3180 VSSIO.n172 VSSIO.n171 0.19776
R3181 VSSIO.n183 VSSIO.n182 0.189315
R3182 VSSIO.n193 VSSIO.n21 0.121322
R3183 VSSIO VSSIO.n202 0.1085
R3184 VSSIO.n107 VSSIO.n61 0.041
R3185 VSSIO.n170 VSSIO 0.0272021
R3186 VSSIO VSSIO.t232 0.0122914
R3187 a_n7856_9000.n20 a_n7856_9000.t0 15.6427
R3188 a_n7856_9000.n39 a_n7856_9000.n0 6.66725
R3189 a_n7856_9000.n38 a_n7856_9000.n1 6.66725
R3190 a_n7856_9000.n37 a_n7856_9000.n2 6.66725
R3191 a_n7856_9000.n36 a_n7856_9000.n3 6.66725
R3192 a_n7856_9000.n35 a_n7856_9000.n4 6.66725
R3193 a_n7856_9000.n34 a_n7856_9000.n5 6.66725
R3194 a_n7856_9000.n33 a_n7856_9000.n6 6.66725
R3195 a_n7856_9000.n32 a_n7856_9000.n7 6.66725
R3196 a_n7856_9000.n31 a_n7856_9000.n8 6.66725
R3197 a_n7856_9000.n30 a_n7856_9000.n9 6.66725
R3198 a_n7856_9000.n29 a_n7856_9000.n10 6.66725
R3199 a_n7856_9000.n28 a_n7856_9000.n11 6.66725
R3200 a_n7856_9000.n27 a_n7856_9000.n12 6.66725
R3201 a_n7856_9000.n26 a_n7856_9000.n13 6.66725
R3202 a_n7856_9000.n25 a_n7856_9000.n14 6.66725
R3203 a_n7856_9000.n24 a_n7856_9000.n15 6.66725
R3204 a_n7856_9000.n23 a_n7856_9000.n16 6.66725
R3205 a_n7856_9000.n22 a_n7856_9000.n17 6.66725
R3206 a_n7856_9000.n21 a_n7856_9000.n18 6.66725
R3207 a_n7856_9000.n20 a_n7856_9000.n19 6.66725
R3208 a_n7856_9000.n59 a_n7856_9000.n58 6.34065
R3209 a_n7856_9000.n78 a_n7856_9000.n77 6.00576
R3210 a_n7856_9000.n59 a_n7856_9000.n57 6.00576
R3211 a_n7856_9000.n60 a_n7856_9000.n56 6.00576
R3212 a_n7856_9000.n61 a_n7856_9000.n55 6.00576
R3213 a_n7856_9000.n62 a_n7856_9000.n54 6.00576
R3214 a_n7856_9000.n63 a_n7856_9000.n53 6.00576
R3215 a_n7856_9000.n64 a_n7856_9000.n52 6.00576
R3216 a_n7856_9000.n65 a_n7856_9000.n51 6.00576
R3217 a_n7856_9000.n66 a_n7856_9000.n50 6.00576
R3218 a_n7856_9000.n67 a_n7856_9000.n49 6.00576
R3219 a_n7856_9000.n68 a_n7856_9000.n48 6.00576
R3220 a_n7856_9000.n69 a_n7856_9000.n47 6.00576
R3221 a_n7856_9000.n70 a_n7856_9000.n46 6.00576
R3222 a_n7856_9000.n71 a_n7856_9000.n45 6.00576
R3223 a_n7856_9000.n72 a_n7856_9000.n44 6.00576
R3224 a_n7856_9000.n73 a_n7856_9000.n43 6.00576
R3225 a_n7856_9000.n74 a_n7856_9000.n42 6.00576
R3226 a_n7856_9000.n75 a_n7856_9000.n41 6.00576
R3227 a_n7856_9000.n76 a_n7856_9000.n40 6.00576
R3228 a_n7856_9000.n77 a_n7856_9000.n39 2.08681
R3229 a_n7856_9000.n0 a_n7856_9000.t1 0.8195
R3230 a_n7856_9000.n0 a_n7856_9000.t2 0.8195
R3231 a_n7856_9000.n1 a_n7856_9000.t3 0.8195
R3232 a_n7856_9000.n1 a_n7856_9000.t4 0.8195
R3233 a_n7856_9000.n2 a_n7856_9000.t5 0.8195
R3234 a_n7856_9000.n2 a_n7856_9000.t6 0.8195
R3235 a_n7856_9000.n3 a_n7856_9000.t7 0.8195
R3236 a_n7856_9000.n3 a_n7856_9000.t8 0.8195
R3237 a_n7856_9000.n4 a_n7856_9000.t9 0.8195
R3238 a_n7856_9000.n4 a_n7856_9000.t10 0.8195
R3239 a_n7856_9000.n5 a_n7856_9000.t11 0.8195
R3240 a_n7856_9000.n5 a_n7856_9000.t12 0.8195
R3241 a_n7856_9000.n6 a_n7856_9000.t13 0.8195
R3242 a_n7856_9000.n6 a_n7856_9000.t14 0.8195
R3243 a_n7856_9000.n7 a_n7856_9000.t15 0.8195
R3244 a_n7856_9000.n7 a_n7856_9000.t16 0.8195
R3245 a_n7856_9000.n8 a_n7856_9000.t17 0.8195
R3246 a_n7856_9000.n8 a_n7856_9000.t18 0.8195
R3247 a_n7856_9000.n9 a_n7856_9000.t19 0.8195
R3248 a_n7856_9000.n9 a_n7856_9000.t20 0.8195
R3249 a_n7856_9000.n10 a_n7856_9000.t21 0.8195
R3250 a_n7856_9000.n10 a_n7856_9000.t22 0.8195
R3251 a_n7856_9000.n11 a_n7856_9000.t23 0.8195
R3252 a_n7856_9000.n11 a_n7856_9000.t24 0.8195
R3253 a_n7856_9000.n12 a_n7856_9000.t25 0.8195
R3254 a_n7856_9000.n12 a_n7856_9000.t26 0.8195
R3255 a_n7856_9000.n13 a_n7856_9000.t27 0.8195
R3256 a_n7856_9000.n13 a_n7856_9000.t28 0.8195
R3257 a_n7856_9000.n14 a_n7856_9000.t29 0.8195
R3258 a_n7856_9000.n14 a_n7856_9000.t30 0.8195
R3259 a_n7856_9000.n15 a_n7856_9000.t31 0.8195
R3260 a_n7856_9000.n15 a_n7856_9000.t32 0.8195
R3261 a_n7856_9000.n16 a_n7856_9000.t33 0.8195
R3262 a_n7856_9000.n16 a_n7856_9000.t34 0.8195
R3263 a_n7856_9000.n17 a_n7856_9000.t35 0.8195
R3264 a_n7856_9000.n17 a_n7856_9000.t36 0.8195
R3265 a_n7856_9000.n18 a_n7856_9000.t37 0.8195
R3266 a_n7856_9000.n18 a_n7856_9000.t38 0.8195
R3267 a_n7856_9000.n19 a_n7856_9000.t39 0.8195
R3268 a_n7856_9000.n19 a_n7856_9000.t40 0.8195
R3269 a_n7856_9000.t79 a_n7856_9000.n78 0.3645
R3270 a_n7856_9000.n78 a_n7856_9000.t80 0.3645
R3271 a_n7856_9000.n58 a_n7856_9000.t41 0.3645
R3272 a_n7856_9000.n58 a_n7856_9000.t42 0.3645
R3273 a_n7856_9000.n57 a_n7856_9000.t43 0.3645
R3274 a_n7856_9000.n57 a_n7856_9000.t44 0.3645
R3275 a_n7856_9000.n56 a_n7856_9000.t45 0.3645
R3276 a_n7856_9000.n56 a_n7856_9000.t46 0.3645
R3277 a_n7856_9000.n55 a_n7856_9000.t47 0.3645
R3278 a_n7856_9000.n55 a_n7856_9000.t48 0.3645
R3279 a_n7856_9000.n54 a_n7856_9000.t49 0.3645
R3280 a_n7856_9000.n54 a_n7856_9000.t50 0.3645
R3281 a_n7856_9000.n53 a_n7856_9000.t51 0.3645
R3282 a_n7856_9000.n53 a_n7856_9000.t52 0.3645
R3283 a_n7856_9000.n52 a_n7856_9000.t53 0.3645
R3284 a_n7856_9000.n52 a_n7856_9000.t54 0.3645
R3285 a_n7856_9000.n51 a_n7856_9000.t55 0.3645
R3286 a_n7856_9000.n51 a_n7856_9000.t56 0.3645
R3287 a_n7856_9000.n50 a_n7856_9000.t57 0.3645
R3288 a_n7856_9000.n50 a_n7856_9000.t58 0.3645
R3289 a_n7856_9000.n49 a_n7856_9000.t59 0.3645
R3290 a_n7856_9000.n49 a_n7856_9000.t60 0.3645
R3291 a_n7856_9000.n48 a_n7856_9000.t61 0.3645
R3292 a_n7856_9000.n48 a_n7856_9000.t62 0.3645
R3293 a_n7856_9000.n47 a_n7856_9000.t63 0.3645
R3294 a_n7856_9000.n47 a_n7856_9000.t64 0.3645
R3295 a_n7856_9000.n46 a_n7856_9000.t65 0.3645
R3296 a_n7856_9000.n46 a_n7856_9000.t66 0.3645
R3297 a_n7856_9000.n45 a_n7856_9000.t67 0.3645
R3298 a_n7856_9000.n45 a_n7856_9000.t68 0.3645
R3299 a_n7856_9000.n44 a_n7856_9000.t69 0.3645
R3300 a_n7856_9000.n44 a_n7856_9000.t70 0.3645
R3301 a_n7856_9000.n43 a_n7856_9000.t71 0.3645
R3302 a_n7856_9000.n43 a_n7856_9000.t72 0.3645
R3303 a_n7856_9000.n42 a_n7856_9000.t73 0.3645
R3304 a_n7856_9000.n42 a_n7856_9000.t74 0.3645
R3305 a_n7856_9000.n41 a_n7856_9000.t75 0.3645
R3306 a_n7856_9000.n41 a_n7856_9000.t76 0.3645
R3307 a_n7856_9000.n40 a_n7856_9000.t77 0.3645
R3308 a_n7856_9000.n40 a_n7856_9000.t78 0.3645
R3309 a_n7856_9000.n60 a_n7856_9000.n59 0.335384
R3310 a_n7856_9000.n61 a_n7856_9000.n60 0.335384
R3311 a_n7856_9000.n62 a_n7856_9000.n61 0.335384
R3312 a_n7856_9000.n63 a_n7856_9000.n62 0.335384
R3313 a_n7856_9000.n64 a_n7856_9000.n63 0.335384
R3314 a_n7856_9000.n65 a_n7856_9000.n64 0.335384
R3315 a_n7856_9000.n66 a_n7856_9000.n65 0.335384
R3316 a_n7856_9000.n67 a_n7856_9000.n66 0.335384
R3317 a_n7856_9000.n68 a_n7856_9000.n67 0.335384
R3318 a_n7856_9000.n69 a_n7856_9000.n68 0.335384
R3319 a_n7856_9000.n70 a_n7856_9000.n69 0.335384
R3320 a_n7856_9000.n71 a_n7856_9000.n70 0.335384
R3321 a_n7856_9000.n72 a_n7856_9000.n71 0.335384
R3322 a_n7856_9000.n73 a_n7856_9000.n72 0.335384
R3323 a_n7856_9000.n74 a_n7856_9000.n73 0.335384
R3324 a_n7856_9000.n75 a_n7856_9000.n74 0.335384
R3325 a_n7856_9000.n76 a_n7856_9000.n75 0.335384
R3326 a_n7856_9000.n77 a_n7856_9000.n76 0.335384
R3327 a_n7856_9000.n39 a_n7856_9000.n38 0.253132
R3328 a_n7856_9000.n38 a_n7856_9000.n37 0.253132
R3329 a_n7856_9000.n37 a_n7856_9000.n36 0.253132
R3330 a_n7856_9000.n36 a_n7856_9000.n35 0.253132
R3331 a_n7856_9000.n35 a_n7856_9000.n34 0.253132
R3332 a_n7856_9000.n34 a_n7856_9000.n33 0.253132
R3333 a_n7856_9000.n33 a_n7856_9000.n32 0.253132
R3334 a_n7856_9000.n32 a_n7856_9000.n31 0.253132
R3335 a_n7856_9000.n31 a_n7856_9000.n30 0.253132
R3336 a_n7856_9000.n30 a_n7856_9000.n29 0.253132
R3337 a_n7856_9000.n29 a_n7856_9000.n28 0.253132
R3338 a_n7856_9000.n28 a_n7856_9000.n27 0.253132
R3339 a_n7856_9000.n27 a_n7856_9000.n26 0.253132
R3340 a_n7856_9000.n26 a_n7856_9000.n25 0.253132
R3341 a_n7856_9000.n25 a_n7856_9000.n24 0.253132
R3342 a_n7856_9000.n24 a_n7856_9000.n23 0.253132
R3343 a_n7856_9000.n23 a_n7856_9000.n22 0.253132
R3344 a_n7856_9000.n22 a_n7856_9000.n21 0.253132
R3345 a_n7856_9000.n21 a_n7856_9000.n20 0.253132
R3346 a_628_11080.t0 a_628_11080.t1 6.08195
R3347 a_n3172_11080.t0 a_n3172_11080.t1 6.08195
R3348 a_n4804_11920.t0 a_n4804_11920.t1 10.5985
R3349 a_2028_11080.t3 a_2028_11080.t2 96.4648
R3350 a_2028_11080.n0 a_2028_11080.t3 56.8672
R3351 a_2028_11080.n0 a_2028_11080.t0 5.15205
R3352 a_2028_11080.t1 a_2028_11080.n0 2.69247
R3353 a_628_11920.t4 a_628_11920.t3 96.4648
R3354 a_628_11920.n0 a_628_11920.t4 51.971
R3355 a_628_11920.n0 a_628_11920.t0 9.50876
R3356 a_628_11920.n1 a_628_11920.n0 5.063
R3357 a_628_11920.n1 a_628_11920.t1 4.87376
R3358 a_628_11920.t2 a_628_11920.n1 2.97195
R3359 a_n972_11080.t3 a_n972_11080.t2 96.4648
R3360 a_n972_11080.n0 a_n972_11080.t3 55.4272
R3361 a_n972_11080.n0 a_n972_11080.t0 5.15205
R3362 a_n972_11080.t1 a_n972_11080.n0 2.69247
R3363 a_n1772_11080.t3 a_n1772_11080.t2 96.4648
R3364 a_n1772_11080.n0 a_n1772_11080.t3 54.9472
R3365 a_n1772_11080.n0 a_n1772_11080.t1 5.15205
R3366 a_n1772_11080.t0 a_n1772_11080.n0 2.69247
R3367 a_n3172_11920.t4 a_n3172_11920.t3 96.4648
R3368 a_n3172_11920.n0 a_n3172_11920.t4 50.051
R3369 a_n3172_11920.n0 a_n3172_11920.t1 9.50876
R3370 a_n3172_11920.n1 a_n3172_11920.n0 5.063
R3371 a_n3172_11920.n1 a_n3172_11920.t0 4.87376
R3372 a_n3172_11920.t2 a_n3172_11920.n1 2.97195
R3373 a_n6172_11080.t3 a_n6172_11080.t2 96.4648
R3374 a_n6172_11080.n0 a_n6172_11080.t3 55.5652
R3375 a_n6172_11080.n0 a_n6172_11080.t0 5.15205
R3376 a_n6172_11080.t1 a_n6172_11080.n0 2.69247
R3377 a_n4948_11920.t6 a_n4948_11920.t4 96.4648
R3378 a_n4948_11920.t5 a_n4948_11920.t3 96.4648
R3379 a_n4948_11920.n0 a_n4948_11920.t5 45.179
R3380 a_n4948_11920.n0 a_n4948_11920.t6 41.759
R3381 a_n4948_11920.n2 a_n4948_11920.t1 10.1312
R3382 a_n4948_11920.n1 a_n4948_11920.n0 7.8772
R3383 a_n4948_11920.n1 a_n4948_11920.t2 7.09797
R3384 a_n4948_11920.t0 a_n4948_11920.n2 7.09797
R3385 a_n4948_11920.n2 a_n4948_11920.n1 0.607022
R3386 a_n5372_11080.t3 a_n5372_11080.t2 119.407
R3387 a_n5372_11080.n0 a_n5372_11080.t3 53.8564
R3388 a_n5372_11080.n0 a_n5372_11080.t0 5.15205
R3389 a_n5372_11080.t1 a_n5372_11080.n0 2.69247
C0 GP VDDIO 7.34963f
C1 PAD VSSIO 0.19113p
C2 GN VSSIO 12.2084f
C3 GP VSSIO 8.30949f
C4 PU_OK VSSIO 4.38433f
C5 OE_N VSSIO 4.52714f
C6 OUT VSSIO 5.80163f
C7 VDDIO VSSIO 85.85404f
C8 VDDIO.t100 VSSIO 2.96988f
C9 OUT.n0 VSSIO 2.73011f
C10 GP.n39 VSSIO 2.06022f
.ends
