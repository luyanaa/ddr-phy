* SPICE3 file created from gf180_pad_core_flat.ext - technology: gf180mcuD

.option scale=5n

.subckt gf180_pad_core_flat GP GN PAD VSSIO VDDIO IN OUT OE_N PU_OK
X0 VSSIO.t227 GN.t2 a_n7856_9000.t39 VSSIO.t226 nfet_03v3 ad=35.2n pd=0.976m as=20.8n ps=0.504m w=400 l=56
X1 a_n7856_9000.t56 GP.t25 VDDIO.t53 VDDIO.t52 pfet_03v3 ad=52n pd=1.104m as=52n ps=1.104m w=1000 l=56
X2 VSSIO.t89 VSSIO.t87 PAD.t21 VSSIO.t88 nfet_03v3 ad=41.6n pd=0.904m as=41.6n ps=0.904m w=800 l=56
X3 a_n7856_9000.t16 GN.t25 VSSIO.t179 VSSIO.t178 nfet_03v3 ad=20.8n pd=0.504m as=20.8n ps=0.504m w=400 l=56
X4 VDDIO.t97 GP.t2 a_n7856_9000.t79 VDDIO.t96 pfet_03v3 ad=88n pd=2.176m as=52n ps=1.104m w=1000 l=56
X5 VSSIO.t71 VSSIO.t69 PAD.t18 VSSIO.t70 nfet_03v3 ad=41.6n pd=0.904m as=41.6n ps=0.904m w=800 l=56
X6 VDDIO.t39 GP.t32 a_n7856_9000.t49 VDDIO.t38 pfet_03v3 ad=52n pd=1.104m as=52n ps=1.104m w=1000 l=56
X7 a_n4804_11920.t1 PU_OK.t1 a_n4948_11920.t1 VSSIO.t228 nfet_03v3 ad=17.6n pd=0.576m as=17.6n ps=0.576m w=200 l=56
X8 a_n3172_11920.t1 a_n6172_11080.t2 a_n3172_11080.t1 VDDIO.t2 pfet_03v3 ad=35.2n pd=0.976m as=35.2n ps=0.976m w=400 l=56
X9 PAD.t11 VSSIO.t78 VSSIO.t80 VSSIO.t79 nfet_03v3 ad=41.6n pd=0.904m as=41.6n ps=0.904m w=800 l=56
X10 VSSIO.t197 GN.t18 a_n7856_9000.t23 VSSIO.t196 nfet_03v3 ad=20.8n pd=0.504m as=20.8n ps=0.504m w=400 l=56
X11 a_n7856_9000.t72 GP.t9 VDDIO.t85 VDDIO.t84 pfet_03v3 ad=52n pd=1.104m as=52n ps=1.104m w=1000 l=56
X12 a_n7856_9000.t50 GP.t31 VDDIO.t41 VDDIO.t40 pfet_03v3 ad=52n pd=1.104m as=52n ps=1.104m w=1000 l=56
X13 VSSIO.t53 VSSIO.t51 PAD.t27 VSSIO.t52 nfet_03v3 ad=41.6n pd=0.904m as=41.6n ps=0.904m w=800 l=56
X14 VSSIO.t145 a_n5372_11080.t3 a_n4804_11920.t0 VSSIO.t144 nfet_03v3 ad=17.6n pd=0.576m as=17.6n ps=0.576m w=200 l=56
X15 VSSIO.t203 GN.t16 a_n7856_9000.t25 VSSIO.t202 nfet_03v3 ad=20.8n pd=0.504m as=20.8n ps=0.504m w=400 l=56
X16 a_n3172_11920.t2 a_n6172_11080.t3 VSSIO.t141 VSSIO.t140 nfet_03v3 ad=17.6n pd=0.576m as=17.6n ps=0.576m w=200 l=56
X17 a_n7856_9000.t42 GP.t39 VDDIO.t25 VDDIO.t24 pfet_03v3 ad=52n pd=1.104m as=52n ps=1.104m w=1000 l=56
X18 PAD.t12 VSSIO.t60 VSSIO.t62 VSSIO.t61 nfet_03v3 ad=41.6n pd=0.904m as=41.6n ps=0.904m w=800 l=56
X19 a_n7856_9000.t22 GN.t19 VSSIO.t201 VSSIO.t200 nfet_03v3 ad=20.8n pd=0.504m as=20.8n ps=0.504m w=400 l=56
X20 VDDIO.t91 GP.t8 a_n7856_9000.t73 VDDIO.t90 pfet_03v3 ad=52n pd=1.104m as=52n ps=1.104m w=1000 l=56
X21 a_n7856_9000.t30 GN.t11 VSSIO.t209 VSSIO.t208 nfet_03v3 ad=20.8n pd=0.504m as=20.8n ps=0.504m w=400 l=56
X22 a_n972_11080.t0 a_n1772_11080.t2 VDDIO.t101 VDDIO.t100 pfet_03v3 ad=35.2n pd=0.976m as=35.2n ps=0.976m w=400 l=56
X23 PAD.t24 VSSIO.t102 VSSIO.t104 VSSIO.t103 nfet_03v3 ad=41.6n pd=0.904m as=41.6n ps=0.904m w=800 l=56
X24 VDDIO.t23 GP.t38 a_n7856_9000.t43 VDDIO.t22 pfet_03v3 ad=52n pd=1.104m as=52n ps=1.104m w=1000 l=56
X25 PAD.t6 VSSIO.t12 VSSIO.t14 VSSIO.t13 nfet_03v3 ad=41.6n pd=0.904m as=41.6n ps=0.904m w=800 l=56
X26 a_n972_11080.t1 a_n1772_11080.t3 VSSIO.t231 VSSIO.t230 nfet_03v3 ad=17.6n pd=0.576m as=17.6n ps=0.576m w=200 l=56
X27 VSSIO.t185 GN.t12 a_n7856_9000.t29 VSSIO.t184 nfet_03v3 ad=20.8n pd=0.504m as=20.8n ps=0.504m w=400 l=56
X28 a_n7856_9000.t66 GP.t15 VDDIO.t79 VDDIO.t78 pfet_03v3 ad=52n pd=1.104m as=52n ps=1.104m w=1000 l=56
X29 PAD.t38 VSSIO.t84 VSSIO.t86 VSSIO.t85 nfet_03v3 ad=41.6n pd=0.904m as=41.6n ps=0.904m w=800 l=56
X30 VSSIO.t211 GN.t10 a_n7856_9000.t31 VSSIO.t210 nfet_03v3 ad=20.8n pd=0.504m as=20.8n ps=0.504m w=400 l=56
X31 a_n7856_9000.t64 GP.t17 VDDIO.t69 VDDIO.t68 pfet_03v3 ad=52n pd=1.104m as=52n ps=1.104m w=1000 l=56
D0 VSSIO.t232 VDDIO.t102 diode_pd2nw_03v3 pj=8000 area=4e+06
X32 VSSIO.t157 GN.t38 a_n7856_9000.t3 VSSIO.t156 nfet_03v3 ad=20.8n pd=0.504m as=20.8n ps=0.504m w=400 l=56
D1 VSSIO.t128 PAD.t44 diode_nd2ps_03v3 pj=6400 area=2.56e+06
X33 VSSIO.t95 VSSIO.t93 PAD.t32 VSSIO.t94 nfet_03v3 ad=41.6n pd=0.904m as=41.6n ps=0.904m w=800 l=56
X34 VSSIO.t29 VSSIO.t27 PAD.t5 VSSIO.t28 nfet_03v3 ad=41.6n pd=0.904m as=41.6n ps=0.904m w=800 l=56
X35 a_n7856_9000.t8 GN.t33 VSSIO.t165 VSSIO.t164 nfet_03v3 ad=20.8n pd=0.504m as=20.8n ps=0.504m w=400 l=56
X36 a_n7856_9000.t2 GN.t39 VSSIO.t153 VSSIO.t152 nfet_03v3 ad=20.8n pd=0.504m as=20.8n ps=0.504m w=400 l=56
X37 PAD.t15 VSSIO.t66 VSSIO.t68 VSSIO.t67 nfet_03v3 ad=41.6n pd=0.904m as=41.6n ps=0.904m w=800 l=56
X38 a_n7856_9000.t36 GN.t5 VSSIO.t221 VSSIO.t220 nfet_03v3 ad=20.8n pd=0.504m as=20.8n ps=0.504m w=400 l=56
X39 VDDIO.t57 GP.t22 a_n7856_9000.t59 VDDIO.t56 pfet_03v3 ad=52n pd=1.104m as=52n ps=1.104m w=1000 l=56
X40 a_n7856_9000.t38 GN.t3 VSSIO.t223 VSSIO.t222 nfet_03v3 ad=20.8n pd=0.504m as=20.8n ps=0.504m w=400 l=56
X41 VSSIO.t155 GN.t34 a_n7856_9000.t7 VSSIO.t154 nfet_03v3 ad=20.8n pd=0.504m as=20.8n ps=0.504m w=400 l=56
X42 VDDIO.t51 GP.t24 a_n7856_9000.t57 VDDIO.t50 pfet_03v3 ad=52n pd=1.104m as=52n ps=1.104m w=1000 l=56
X43 VSSIO.t77 VSSIO.t75 PAD.t35 VSSIO.t76 nfet_03v3 ad=41.6n pd=0.904m as=41.6n ps=0.904m w=800 l=56
X44 a_n7856_9000.t60 GP.t21 VDDIO.t65 VDDIO.t64 pfet_03v3 ad=52n pd=1.104m as=52n ps=1.104m w=1000 l=56
X45 VSSIO.t225 GN.t4 a_n7856_9000.t37 VSSIO.t224 nfet_03v3 ad=20.8n pd=0.504m as=20.8n ps=0.504m w=400 l=56
X46 VSSIO.t183 GN.t26 a_n7856_9000.t15 VSSIO.t182 nfet_03v3 ad=20.8n pd=0.504m as=20.8n ps=0.504m w=400 l=56
X47 VSSIO.t119 VSSIO.t117 PAD.t33 VSSIO.t118 nfet_03v3 ad=41.6n pd=0.904m as=41.6n ps=0.904m w=800 l=56
X48 IN.t1 PAD.t42 VSSIO.t133 VSSIO.t132 nfet_03v3 ad=35.2n pd=0.976m as=35.2n ps=0.976m w=400 l=56
X49 a_n7856_9000.t58 GP.t23 VDDIO.t55 VDDIO.t54 pfet_03v3 ad=52n pd=1.104m as=52n ps=1.104m w=1000 l=56
X50 a_n7856_9000.t52 GP.t29 VDDIO.t43 VDDIO.t42 pfet_03v3 ad=52n pd=1.104m as=52n ps=1.104m w=1000 l=56
X51 a_n7856_9000.t14 GN.t27 VSSIO.t177 VSSIO.t176 nfet_03v3 ad=20.8n pd=0.504m as=20.8n ps=0.504m w=400 l=56
X52 VSSIO.t101 VSSIO.t99 PAD.t37 VSSIO.t100 nfet_03v3 ad=41.6n pd=0.904m as=41.6n ps=0.904m w=800 l=56
X53 VDDIO.t45 GP.t28 a_n7856_9000.t53 VDDIO.t44 pfet_03v3 ad=52n pd=1.104m as=52n ps=1.104m w=1000 l=56
X54 VSSIO.t11 VSSIO.t9 PAD.t8 VSSIO.t10 nfet_03v3 ad=41.6n pd=0.904m as=41.6n ps=0.904m w=800 l=56
X55 VDDIO.t37 GP.t30 a_n7856_9000.t51 VDDIO.t36 pfet_03v3 ad=52n pd=1.104m as=52n ps=1.104m w=1000 l=56
X56 PAD.t36 VSSIO.t108 VSSIO.t110 VSSIO.t109 nfet_03v3 ad=41.6n pd=0.904m as=41.6n ps=0.904m w=800 l=56
X57 PAD.t9 VSSIO.t18 VSSIO.t20 VSSIO.t19 nfet_03v3 ad=41.6n pd=0.904m as=41.6n ps=0.904m w=800 l=56
X58 PAD.t3 VSSIO.t42 VSSIO.t44 VSSIO.t43 nfet_03v3 ad=41.6n pd=0.904m as=41.6n ps=0.904m w=800 l=56
X59 VSSIO.t83 VSSIO.t81 PAD.t7 VSSIO.t82 nfet_03v3 ad=41.6n pd=0.904m as=41.6n ps=0.904m w=800 l=56
X60 VSSIO.t193 GN.t20 a_n7856_9000.t21 VSSIO.t192 nfet_03v3 ad=20.8n pd=0.504m as=20.8n ps=0.504m w=400 l=56
X61 a_n7856_9000.t74 GP.t7 VDDIO.t89 VDDIO.t88 pfet_03v3 ad=52n pd=1.104m as=52n ps=1.104m w=1000 l=56
X62 a_n1772_11080.t1 a_n3172_11920.t3 VDDIO.t13 VDDIO.t12 pfet_03v3 ad=35.2n pd=0.976m as=35.2n ps=0.976m w=400 l=56
X63 a_n7856_9000.t46 GP.t35 VDDIO.t31 VDDIO.t30 pfet_03v3 ad=52n pd=1.104m as=52n ps=1.104m w=1000 l=56
X64 PAD.t22 VSSIO.t90 VSSIO.t92 VSSIO.t91 nfet_03v3 ad=41.6n pd=0.904m as=41.6n ps=0.904m w=800 l=56
X65 a_n7856_9000.t44 GP.t37 VDDIO.t27 VDDIO.t26 pfet_03v3 ad=52n pd=1.104m as=52n ps=1.104m w=1000 l=56
X66 PAD.t10 VSSIO.t24 VSSIO.t26 VSSIO.t25 nfet_03v3 ad=41.6n pd=0.904m as=41.6n ps=0.904m w=800 l=56
X67 VDDIO.t87 GP.t6 a_n7856_9000.t75 VDDIO.t86 pfet_03v3 ad=52n pd=1.104m as=52n ps=1.104m w=1000 l=56
X68 a_2028_11080.t1 a_628_11920.t3 VDDIO.t109 VDDIO.t108 pfet_03v3 ad=35.2n pd=0.976m as=35.2n ps=0.976m w=400 l=56
X69 a_n1772_11080.t0 a_n3172_11920.t4 VSSIO.t3 VSSIO.t2 nfet_03v3 ad=17.6n pd=0.576m as=17.6n ps=0.576m w=200 l=56
X70 a_n7856_9000.t28 GN.t13 VSSIO.t207 VSSIO.t206 nfet_03v3 ad=20.8n pd=0.504m as=20.8n ps=0.504m w=400 l=56
X71 VSSIO.t35 VSSIO.t33 PAD.t29 VSSIO.t34 nfet_03v3 ad=41.6n pd=0.904m as=41.6n ps=0.904m w=800 l=56
X72 VDDIO.t77 GP.t14 a_n7856_9000.t67 VDDIO.t76 pfet_03v3 ad=52n pd=1.104m as=52n ps=1.104m w=1000 l=56
X73 VDDIO.t29 GP.t36 a_n7856_9000.t45 VDDIO.t28 pfet_03v3 ad=52n pd=1.104m as=52n ps=1.104m w=1000 l=56
X74 a_2028_11080.t0 a_628_11920.t4 VSSIO.t139 VSSIO.t138 nfet_03v3 ad=17.6n pd=0.576m as=17.6n ps=0.576m w=200 l=56
X75 a_n7856_9000.t0 GN.t41 VSSIO.t149 VSSIO.t148 nfet_03v3 ad=20.8n pd=0.504m as=35.2n ps=0.976m w=400 l=56
X76 VSSIO.t199 GN.t14 a_n7856_9000.t27 VSSIO.t198 nfet_03v3 ad=20.8n pd=0.504m as=20.8n ps=0.504m w=400 l=56
X77 a_n7856_9000.t68 GP.t13 VDDIO.t75 VDDIO.t74 pfet_03v3 ad=52n pd=1.104m as=52n ps=1.104m w=1000 l=56
X78 a_n4948_11920.t2 PU_OK.t0 VDDIO.t99 VDDIO.t98 pfet_03v3 ad=35.2n pd=0.976m as=35.2n ps=0.976m w=400 l=56
X79 VSSIO.t151 GN.t40 a_n7856_9000.t1 VSSIO.t150 nfet_03v3 ad=20.8n pd=0.504m as=20.8n ps=0.504m w=400 l=56
X80 a_n7856_9000.t40 GP.t41 VDDIO.t19 VDDIO.t18 pfet_03v3 ad=52n pd=1.104m as=88n ps=2.176m w=1000 l=56
X81 VSSIO.t219 GN.t6 a_n7856_9000.t35 VSSIO.t218 nfet_03v3 ad=20.8n pd=0.504m as=20.8n ps=0.504m w=400 l=56
X82 VSSIO.t125 VSSIO.t123 PAD.t23 VSSIO.t124 nfet_03v3 ad=70.4n pd=1.776m as=41.6n ps=0.904m w=800 l=56
X83 a_n7856_9000.t80 PAD.t40 VSSIO.t229 ppolyf_u r_width=4400 r_length=280
X84 a_n7856_9000.t6 GN.t35 VSSIO.t159 VSSIO.t158 nfet_03v3 ad=20.8n pd=0.504m as=20.8n ps=0.504m w=400 l=56
X85 a_n4948_11920.t0 a_n5372_11080.t2 VDDIO.t17 VDDIO.t16 pfet_03v3 ad=35.2n pd=0.976m as=35.2n ps=0.976m w=400 l=56
X86 a_n7856_9000.t34 GN.t7 VSSIO.t217 VSSIO.t216 nfet_03v3 ad=20.8n pd=0.504m as=20.8n ps=0.504m w=400 l=56
X87 VDDIO.t59 GP.t20 a_n7856_9000.t61 VDDIO.t58 pfet_03v3 ad=52n pd=1.104m as=52n ps=1.104m w=1000 l=56
X88 VSSIO.t107 VSSIO.t105 PAD.t31 VSSIO.t106 nfet_03v3 ad=41.6n pd=0.904m as=41.6n ps=0.904m w=800 l=56
X89 VSSIO.t17 VSSIO.t15 PAD.t16 VSSIO.t16 nfet_03v3 ad=41.6n pd=0.904m as=41.6n ps=0.904m w=800 l=56
X90 GN.t0 a_2028_11080.t2 VDDIO.t15 VDDIO.t14 pfet_03v3 ad=35.2n pd=0.976m as=35.2n ps=0.976m w=400 l=56
X91 VSSIO.t171 GN.t30 a_n7856_9000.t11 VSSIO.t170 nfet_03v3 ad=20.8n pd=0.504m as=20.8n ps=0.504m w=400 l=56
X92 VSSIO.t175 GN.t28 a_n7856_9000.t13 VSSIO.t174 nfet_03v3 ad=20.8n pd=0.504m as=20.8n ps=0.504m w=400 l=56
X93 PAD.t30 VSSIO.t114 VSSIO.t116 VSSIO.t115 nfet_03v3 ad=41.6n pd=0.904m as=41.6n ps=0.904m w=800 l=56
X94 PAD.t17 VSSIO.t48 VSSIO.t50 VSSIO.t49 nfet_03v3 ad=41.6n pd=0.904m as=41.6n ps=0.904m w=800 l=56
X95 GN.t1 a_2028_11080.t3 VSSIO.t147 VSSIO.t146 nfet_03v3 ad=17.6n pd=0.576m as=17.6n ps=0.576m w=200 l=56
X96 a_n7856_9000.t54 GP.t27 VDDIO.t47 VDDIO.t46 pfet_03v3 ad=52n pd=1.104m as=52n ps=1.104m w=1000 l=56
X97 a_n7856_9000.t12 GN.t29 VSSIO.t173 VSSIO.t172 nfet_03v3 ad=20.8n pd=0.504m as=20.8n ps=0.504m w=400 l=56
X98 VSSIO.t59 VSSIO.t57 PAD.t26 VSSIO.t58 nfet_03v3 ad=41.6n pd=0.904m as=41.6n ps=0.904m w=800 l=56
X99 PAD.t34 VSSIO.t96 VSSIO.t98 VSSIO.t97 nfet_03v3 ad=41.6n pd=0.904m as=41.6n ps=0.904m w=800 l=56
X100 a_n7856_9000.t18 GN.t23 VSSIO.t181 VSSIO.t180 nfet_03v3 ad=20.8n pd=0.504m as=20.8n ps=0.504m w=400 l=56
X101 PAD.t1 VSSIO.t30 VSSIO.t32 VSSIO.t31 nfet_03v3 ad=41.6n pd=0.904m as=41.6n ps=0.904m w=800 l=56
X102 a_n5372_11080.t1 OE_N.t0 VDDIO.t4 VDDIO.t3 pfet_03v3 ad=35.2n pd=0.976m as=35.2n ps=0.976m w=400 l=56
X103 VDDIO.t93 GP.t4 a_n7856_9000.t77 VDDIO.t92 pfet_03v3 ad=52n pd=1.104m as=52n ps=1.104m w=1000 l=56
X104 VDDIO.t49 GP.t26 a_n7856_9000.t55 VDDIO.t48 pfet_03v3 ad=52n pd=1.104m as=52n ps=1.104m w=1000 l=56
X105 a_628_11920.t1 OUT.t0 a_628_11080.t0 VDDIO.t11 pfet_03v3 ad=35.2n pd=0.976m as=35.2n ps=0.976m w=400 l=56
X106 a_n7856_9000.t20 GN.t21 VSSIO.t191 VSSIO.t190 nfet_03v3 ad=20.8n pd=0.504m as=20.8n ps=0.504m w=400 l=56
X107 VSSIO.t41 VSSIO.t39 PAD.t14 VSSIO.t40 nfet_03v3 ad=41.6n pd=0.904m as=41.6n ps=0.904m w=800 l=56
D2 VSSIO.t130 PAD.t43 diode_nd2ps_03v3 pj=6400 area=2.56e+06
X108 VSSIO.t187 GN.t24 a_n7856_9000.t17 VSSIO.t186 nfet_03v3 ad=20.8n pd=0.504m as=20.8n ps=0.504m w=400 l=56
X109 VDDIO.t33 GP.t34 a_n7856_9000.t47 VDDIO.t32 pfet_03v3 ad=52n pd=1.104m as=52n ps=1.104m w=1000 l=56
X110 a_n5372_11080.t0 OE_N.t1 VSSIO.t127 VSSIO.t126 nfet_03v3 ad=17.6n pd=0.576m as=17.6n ps=0.576m w=200 l=56
X111 a_628_11920.t2 OUT.t2 VSSIO.t137 VSSIO.t136 nfet_03v3 ad=17.6n pd=0.576m as=17.6n ps=0.576m w=200 l=56
X112 a_n7856_9000.t78 GP.t3 VDDIO.t95 VDDIO.t94 pfet_03v3 ad=52n pd=1.104m as=52n ps=1.104m w=1000 l=56
X113 VSSIO.t189 GN.t22 a_n7856_9000.t19 VSSIO.t188 nfet_03v3 ad=20.8n pd=0.504m as=20.8n ps=0.504m w=400 l=56
X114 a_n7856_9000.t76 GP.t5 VDDIO.t63 VDDIO.t62 pfet_03v3 ad=52n pd=1.104m as=52n ps=1.104m w=1000 l=56
X115 PAD.t19 VSSIO.t120 VSSIO.t122 VSSIO.t121 nfet_03v3 ad=41.6n pd=0.904m as=41.6n ps=0.904m w=800 l=56
X116 a_n7856_9000.t48 GP.t33 VDDIO.t35 VDDIO.t34 pfet_03v3 ad=52n pd=1.104m as=52n ps=1.104m w=1000 l=56
X117 a_n7856_9000.t24 GN.t17 VSSIO.t205 VSSIO.t204 nfet_03v3 ad=20.8n pd=0.504m as=20.8n ps=0.504m w=400 l=56
X118 VDDIO.t83 GP.t10 a_n7856_9000.t71 VDDIO.t82 pfet_03v3 ad=52n pd=1.104m as=52n ps=1.104m w=1000 l=56
X119 VSSIO.t65 VSSIO.t63 PAD.t25 VSSIO.t64 nfet_03v3 ad=41.6n pd=0.904m as=41.6n ps=0.904m w=800 l=56
X120 a_n7856_9000.t26 GN.t15 VSSIO.t195 VSSIO.t194 nfet_03v3 ad=20.8n pd=0.504m as=20.8n ps=0.504m w=400 l=56
X121 VDDIO.t71 GP.t12 a_n7856_9000.t69 VDDIO.t70 pfet_03v3 ad=52n pd=1.104m as=52n ps=1.104m w=1000 l=56
X122 VDDIO.t21 GP.t40 a_n7856_9000.t41 VDDIO.t20 pfet_03v3 ad=52n pd=1.104m as=52n ps=1.104m w=1000 l=56
X123 PAD.t39 VSSIO.t72 VSSIO.t74 VSSIO.t73 nfet_03v3 ad=41.6n pd=0.904m as=41.6n ps=0.904m w=800 l=56
X124 IN.t0 PAD.t41 VDDIO.t8 VDDIO.t7 pfet_03v3 ad=70.4n pd=1.776m as=70.4n ps=1.776m w=800 l=56
X125 VSSIO.t23 VSSIO.t21 PAD.t28 VSSIO.t22 nfet_03v3 ad=41.6n pd=0.904m as=41.6n ps=0.904m w=800 l=56
X126 VSSIO.t113 VSSIO.t111 PAD.t20 VSSIO.t112 nfet_03v3 ad=41.6n pd=0.904m as=41.6n ps=0.904m w=800 l=56
X127 a_n7856_9000.t70 GP.t11 VDDIO.t81 VDDIO.t80 pfet_03v3 ad=52n pd=1.104m as=52n ps=1.104m w=1000 l=56
X128 VSSIO.t47 VSSIO.t45 PAD.t13 VSSIO.t46 nfet_03v3 ad=41.6n pd=0.904m as=41.6n ps=0.904m w=800 l=56
X129 a_n6172_11080.t1 OUT.t1 VDDIO.t10 VDDIO.t9 pfet_03v3 ad=35.2n pd=0.976m as=35.2n ps=0.976m w=400 l=56
X130 VSSIO.t215 GN.t8 a_n7856_9000.t33 VSSIO.t214 nfet_03v3 ad=20.8n pd=0.504m as=20.8n ps=0.504m w=400 l=56
X131 a_n7856_9000.t62 GP.t19 VDDIO.t61 VDDIO.t60 pfet_03v3 ad=52n pd=1.104m as=52n ps=1.104m w=1000 l=56
X132 VSSIO.t163 GN.t36 a_n7856_9000.t5 VSSIO.t162 nfet_03v3 ad=20.8n pd=0.504m as=20.8n ps=0.504m w=400 l=56
X133 PAD.t4 VSSIO.t54 VSSIO.t56 VSSIO.t55 nfet_03v3 ad=41.6n pd=0.904m as=41.6n ps=0.904m w=800 l=56
X134 a_n6172_11080.t0 OUT.t3 VSSIO.t135 VSSIO.t134 nfet_03v3 ad=17.6n pd=0.576m as=17.6n ps=0.576m w=200 l=56
D3 PAD.t45 VDDIO.t5 diode_pd2nw_03v3 pj=6400 area=2.56e+06
X135 GP.t1 a_n972_11080.t2 VDDIO.t107 VDDIO.t106 pfet_03v3 ad=35.2n pd=0.976m as=35.2n ps=0.976m w=400 l=56
X136 VDDIO.t73 GP.t16 a_n7856_9000.t65 VDDIO.t72 pfet_03v3 ad=52n pd=1.104m as=52n ps=1.104m w=1000 l=56
X137 a_n7856_9000.t32 GN.t9 VSSIO.t213 VSSIO.t212 nfet_03v3 ad=20.8n pd=0.504m as=20.8n ps=0.504m w=400 l=56
X138 a_n7856_9000.t10 GN.t31 VSSIO.t169 VSSIO.t168 nfet_03v3 ad=20.8n pd=0.504m as=20.8n ps=0.504m w=400 l=56
X139 VDDIO.t67 GP.t18 a_n7856_9000.t63 VDDIO.t66 pfet_03v3 ad=52n pd=1.104m as=52n ps=1.104m w=1000 l=56
X140 a_628_11080.t1 a_n4948_11920.t3 VDDIO.t105 VDDIO.t104 pfet_03v3 ad=35.2n pd=0.976m as=35.2n ps=0.976m w=400 l=56
X141 a_n7856_9000.t4 GN.t37 VSSIO.t161 VSSIO.t160 nfet_03v3 ad=20.8n pd=0.504m as=20.8n ps=0.504m w=400 l=56
X142 a_n3172_11080.t0 a_n4948_11920.t4 VDDIO.t1 VDDIO.t0 pfet_03v3 ad=35.2n pd=0.976m as=35.2n ps=0.976m w=400 l=56
X143 PAD.t0 VSSIO.t36 VSSIO.t38 VSSIO.t37 nfet_03v3 ad=41.6n pd=0.904m as=41.6n ps=0.904m w=800 l=56
X144 GP.t0 a_n972_11080.t3 VSSIO.t143 VSSIO.t142 nfet_03v3 ad=17.6n pd=0.576m as=17.6n ps=0.576m w=200 l=56
X145 PAD.t2 VSSIO.t6 VSSIO.t8 VSSIO.t7 nfet_03v3 ad=41.6n pd=0.904m as=70.4n ps=1.776m w=800 l=56
X146 a_628_11920.t0 a_n4948_11920.t5 VSSIO.t5 VSSIO.t4 nfet_03v3 ad=17.6n pd=0.576m as=17.6n ps=0.576m w=200 l=56
X147 VSSIO.t167 GN.t32 a_n7856_9000.t9 VSSIO.t166 nfet_03v3 ad=20.8n pd=0.504m as=20.8n ps=0.504m w=400 l=56
X148 a_n3172_11920.t0 a_n4948_11920.t6 VSSIO.t1 VSSIO.t0 nfet_03v3 ad=17.6n pd=0.576m as=17.6n ps=0.576m w=200 l=56
R0 IN IN.t1 9.17375
R1 IN IN.t0 8.13509
R2 GN.n0 GN.t2 44.2698
R3 GN.n40 GN.n39 38.8567
R4 GN.n40 GN.n38 38.2238
R5 GN.n0 GN.t3 32.5898
R6 GN.n1 GN.t4 32.5898
R7 GN.n2 GN.t5 32.5898
R8 GN.n3 GN.t6 32.5898
R9 GN.n4 GN.t7 32.5898
R10 GN.n5 GN.t8 32.5898
R11 GN.n6 GN.t9 32.5898
R12 GN.n7 GN.t10 32.5898
R13 GN.n8 GN.t11 32.5898
R14 GN.n9 GN.t12 32.5898
R15 GN.n10 GN.t13 32.5898
R16 GN.n11 GN.t14 32.5898
R17 GN.n12 GN.t15 32.5898
R18 GN.n13 GN.t16 32.5898
R19 GN.n14 GN.t17 32.5898
R20 GN.n15 GN.t18 32.5898
R21 GN.n16 GN.t19 32.5898
R22 GN.n17 GN.t20 32.5898
R23 GN.n18 GN.t21 32.5898
R24 GN.n19 GN.t22 32.5898
R25 GN.n20 GN.t23 32.5898
R26 GN.n21 GN.t24 32.5898
R27 GN.n22 GN.t25 32.5898
R28 GN.n23 GN.t26 32.5898
R29 GN.n24 GN.t27 32.5898
R30 GN.n25 GN.t28 32.5898
R31 GN.n26 GN.t29 32.5898
R32 GN.n27 GN.t30 32.5898
R33 GN.n28 GN.t31 32.5898
R34 GN.n29 GN.t32 32.5898
R35 GN.n30 GN.t33 32.5898
R36 GN.n31 GN.t34 32.5898
R37 GN.n32 GN.t35 32.5898
R38 GN.n33 GN.t36 32.5898
R39 GN.n34 GN.t37 32.5898
R40 GN.n35 GN.t38 32.5898
R41 GN.n36 GN.t39 32.5898
R42 GN.n37 GN.t40 32.5898
R43 GN.n38 GN.t41 32.5898
R44 GN.n38 GN.n37 11.6805
R45 GN.n37 GN.n36 11.6805
R46 GN.n36 GN.n35 11.6805
R47 GN.n35 GN.n34 11.6805
R48 GN.n34 GN.n33 11.6805
R49 GN.n33 GN.n32 11.6805
R50 GN.n32 GN.n31 11.6805
R51 GN.n31 GN.n30 11.6805
R52 GN.n30 GN.n29 11.6805
R53 GN.n29 GN.n28 11.6805
R54 GN.n28 GN.n27 11.6805
R55 GN.n27 GN.n26 11.6805
R56 GN.n26 GN.n25 11.6805
R57 GN.n25 GN.n24 11.6805
R58 GN.n24 GN.n23 11.6805
R59 GN.n23 GN.n22 11.6805
R60 GN.n22 GN.n21 11.6805
R61 GN.n21 GN.n20 11.6805
R62 GN.n20 GN.n19 11.6805
R63 GN.n19 GN.n18 11.6805
R64 GN.n18 GN.n17 11.6805
R65 GN.n17 GN.n16 11.6805
R66 GN.n16 GN.n15 11.6805
R67 GN.n15 GN.n14 11.6805
R68 GN.n14 GN.n13 11.6805
R69 GN.n13 GN.n12 11.6805
R70 GN.n12 GN.n11 11.6805
R71 GN.n11 GN.n10 11.6805
R72 GN.n10 GN.n9 11.6805
R73 GN.n9 GN.n8 11.6805
R74 GN.n8 GN.n7 11.6805
R75 GN.n7 GN.n6 11.6805
R76 GN.n6 GN.n5 11.6805
R77 GN.n5 GN.n4 11.6805
R78 GN.n4 GN.n3 11.6805
R79 GN.n3 GN.n2 11.6805
R80 GN.n2 GN.n1 11.6805
R81 GN.n1 GN.n0 11.6805
R82 GN.n39 GN.t1 5.15205
R83 GN.n39 GN.t0 2.69247
R84 GN GN.n40 0.0262143
R85 GP.n0 GP.t2 88.5912
R86 GP.n0 GP.t3 76.9112
R87 GP.n1 GP.t4 76.9112
R88 GP.n2 GP.t5 76.9112
R89 GP.n3 GP.t6 76.9112
R90 GP.n4 GP.t7 76.9112
R91 GP.n5 GP.t8 76.9112
R92 GP.n6 GP.t9 76.9112
R93 GP.n7 GP.t10 76.9112
R94 GP.n8 GP.t11 76.9112
R95 GP.n9 GP.t12 76.9112
R96 GP.n10 GP.t13 76.9112
R97 GP.n11 GP.t14 76.9112
R98 GP.n12 GP.t15 76.9112
R99 GP.n13 GP.t16 76.9112
R100 GP.n14 GP.t17 76.9112
R101 GP.n15 GP.t18 76.9112
R102 GP.n16 GP.t19 76.9112
R103 GP.n17 GP.t20 76.9112
R104 GP.n18 GP.t21 76.9112
R105 GP.n19 GP.t22 76.9112
R106 GP.n20 GP.t23 76.9112
R107 GP.n21 GP.t24 76.9112
R108 GP.n22 GP.t25 76.9112
R109 GP.n23 GP.t26 76.9112
R110 GP.n24 GP.t27 76.9112
R111 GP.n25 GP.t28 76.9112
R112 GP.n26 GP.t29 76.9112
R113 GP.n27 GP.t30 76.9112
R114 GP.n28 GP.t31 76.9112
R115 GP.n29 GP.t32 76.9112
R116 GP.n30 GP.t33 76.9112
R117 GP.n31 GP.t34 76.9112
R118 GP.n32 GP.t35 76.9112
R119 GP.n33 GP.t36 76.9112
R120 GP.n34 GP.t37 76.9112
R121 GP.n35 GP.t38 76.9112
R122 GP.n36 GP.t39 76.9112
R123 GP.n37 GP.t40 76.9112
R124 GP.n38 GP.t41 76.9112
R125 GP.n40 GP.n39 41.6287
R126 GP.n40 GP.n38 38.2238
R127 GP.n38 GP.n37 11.6805
R128 GP.n37 GP.n36 11.6805
R129 GP.n36 GP.n35 11.6805
R130 GP.n35 GP.n34 11.6805
R131 GP.n34 GP.n33 11.6805
R132 GP.n33 GP.n32 11.6805
R133 GP.n32 GP.n31 11.6805
R134 GP.n31 GP.n30 11.6805
R135 GP.n30 GP.n29 11.6805
R136 GP.n29 GP.n28 11.6805
R137 GP.n28 GP.n27 11.6805
R138 GP.n27 GP.n26 11.6805
R139 GP.n26 GP.n25 11.6805
R140 GP.n25 GP.n24 11.6805
R141 GP.n24 GP.n23 11.6805
R142 GP.n23 GP.n22 11.6805
R143 GP.n22 GP.n21 11.6805
R144 GP.n21 GP.n20 11.6805
R145 GP.n20 GP.n19 11.6805
R146 GP.n19 GP.n18 11.6805
R147 GP.n18 GP.n17 11.6805
R148 GP.n17 GP.n16 11.6805
R149 GP.n16 GP.n15 11.6805
R150 GP.n15 GP.n14 11.6805
R151 GP.n14 GP.n13 11.6805
R152 GP.n13 GP.n12 11.6805
R153 GP.n12 GP.n11 11.6805
R154 GP.n11 GP.n10 11.6805
R155 GP.n10 GP.n9 11.6805
R156 GP.n9 GP.n8 11.6805
R157 GP.n8 GP.n7 11.6805
R158 GP.n7 GP.n6 11.6805
R159 GP.n6 GP.n5 11.6805
R160 GP.n5 GP.n4 11.6805
R161 GP.n4 GP.n3 11.6805
R162 GP.n3 GP.n2 11.6805
R163 GP.n2 GP.n1 11.6805
R164 GP.n1 GP.n0 11.6805
R165 GP.n39 GP.t0 5.15205
R166 GP.n39 GP.t1 2.69247
R167 GP GP.n40 0.0262143
R168 PU_OK.t1 PU_OK.t0 119.407
R169 PU_OK PU_OK.t1 52.6952
R170 OE_N.t1 OE_N.t0 96.4648
R171 OE_N OE_N.t1 53.144
R172 OUT.t3 OUT.t1 96.4648
R173 OUT.t2 OUT.t0 96.4648
R174 OUT.n0 OUT.t2 47.237
R175 OUT.n0 OUT.t3 40.559
R176 OUT OUT.n0 12.8255
R177 PAD.n15 PAD.t41 108.495
R178 PAD.n15 PAD.t42 75.5435
R179 PAD.n16 PAD.n15 10.1705
R180 PAD.n111 PAD 7.7513
R181 PAD.n109 PAD.n108 7.13118
R182 PAD.n96 PAD.n95 6.47624
R183 PAD.n72 PAD.n71 6.47624
R184 PAD.n96 PAD.n94 6.11624
R185 PAD.n97 PAD.n93 6.11624
R186 PAD.n98 PAD.n92 6.11624
R187 PAD.n99 PAD.n91 6.11624
R188 PAD.n100 PAD.n90 6.11624
R189 PAD.n101 PAD.n89 6.11624
R190 PAD.n102 PAD.n88 6.11624
R191 PAD.n103 PAD.n87 6.11624
R192 PAD.n104 PAD.n86 6.11624
R193 PAD.n105 PAD.n85 6.11624
R194 PAD.n84 PAD.n64 6.11624
R195 PAD.n83 PAD.n65 6.11624
R196 PAD.n81 PAD.n66 6.11624
R197 PAD.n80 PAD.n67 6.11624
R198 PAD.n69 PAD.n68 6.11624
R199 PAD.n75 PAD.n74 6.11624
R200 PAD.n76 PAD.n73 6.11624
R201 PAD.n72 PAD.n70 6.11624
R202 PAD.n78 PAD.n77 4.9055
R203 PAD.n18 PAD.n16 4.5005
R204 PAD.n79 PAD.n78 4.5005
R205 PAD.n82 PAD.n63 4.5005
R206 PAD.n107 PAD.n106 4.5005
R207 PAD.n108 PAD.n107 3.41726
R208 PAD PAD.n205 1.3199
R209 PAD.n205 PAD 1.3199
R210 PAD.n205 PAD 1.3199
R211 PAD.n95 PAD.t2 0.41
R212 PAD.n95 PAD.t8 0.41
R213 PAD.n94 PAD.t6 0.41
R214 PAD.n94 PAD.t16 0.41
R215 PAD.n93 PAD.t9 0.41
R216 PAD.n93 PAD.t28 0.41
R217 PAD.n92 PAD.t10 0.41
R218 PAD.n92 PAD.t5 0.41
R219 PAD.n91 PAD.t1 0.41
R220 PAD.n91 PAD.t29 0.41
R221 PAD.n90 PAD.t0 0.41
R222 PAD.n90 PAD.t14 0.41
R223 PAD.n89 PAD.t3 0.41
R224 PAD.n89 PAD.t13 0.41
R225 PAD.n88 PAD.t17 0.41
R226 PAD.n88 PAD.t27 0.41
R227 PAD.n87 PAD.t4 0.41
R228 PAD.n87 PAD.t26 0.41
R229 PAD.n86 PAD.t12 0.41
R230 PAD.n86 PAD.t25 0.41
R231 PAD.n85 PAD.t15 0.41
R232 PAD.n85 PAD.t18 0.41
R233 PAD.n64 PAD.t39 0.41
R234 PAD.n64 PAD.t35 0.41
R235 PAD.n65 PAD.t11 0.41
R236 PAD.n65 PAD.t7 0.41
R237 PAD.n66 PAD.t38 0.41
R238 PAD.n66 PAD.t21 0.41
R239 PAD.n67 PAD.t22 0.41
R240 PAD.n67 PAD.t32 0.41
R241 PAD.n68 PAD.t34 0.41
R242 PAD.n68 PAD.t37 0.41
R243 PAD.n74 PAD.t24 0.41
R244 PAD.n74 PAD.t31 0.41
R245 PAD.n73 PAD.t36 0.41
R246 PAD.n73 PAD.t20 0.41
R247 PAD.n70 PAD.t30 0.41
R248 PAD.n70 PAD.t33 0.41
R249 PAD.n71 PAD.t19 0.41
R250 PAD.n71 PAD.t23 0.41
R251 PAD.n107 PAD.n63 0.4055
R252 PAD.n78 PAD.n63 0.4055
R253 PAD.n97 PAD.n96 0.3605
R254 PAD.n98 PAD.n97 0.3605
R255 PAD.n99 PAD.n98 0.3605
R256 PAD.n100 PAD.n99 0.3605
R257 PAD.n101 PAD.n100 0.3605
R258 PAD.n102 PAD.n101 0.3605
R259 PAD.n103 PAD.n102 0.3605
R260 PAD.n104 PAD.n103 0.3605
R261 PAD.n105 PAD.n104 0.3605
R262 PAD.n84 PAD.n83 0.3605
R263 PAD.n81 PAD.n80 0.3605
R264 PAD.n75 PAD.n69 0.3605
R265 PAD.n76 PAD.n75 0.3605
R266 PAD.n77 PAD.n72 0.32675
R267 PAD.n108 PAD 0.310515
R268 PAD.n80 PAD.n79 0.30425
R269 PAD PAD.t40 0.280213
R270 PAD.n106 PAD.n84 0.23675
R271 PAD.n83 PAD.n82 0.21425
R272 PAD.n82 PAD.n81 0.14675
R273 PAD.n202 PAD.n201 0.143024
R274 PAD.n116 PAD.n109 0.143024
R275 PAD.n110 PAD.n109 0.141125
R276 PAD.n203 PAD.n202 0.141125
R277 PAD.n2 PAD.n1 0.141125
R278 PAD.n198 PAD.n197 0.141125
R279 PAD.n7 PAD.n6 0.141125
R280 PAD.n193 PAD.n192 0.141125
R281 PAD.n10 PAD.n9 0.141125
R282 PAD.n186 PAD.n185 0.141125
R283 PAD.n17 PAD.n14 0.141125
R284 PAD.n181 PAD.n180 0.141125
R285 PAD.n21 PAD.n20 0.141125
R286 PAD.n174 PAD.n173 0.141125
R287 PAD.n26 PAD.n25 0.141125
R288 PAD.n169 PAD.n168 0.141125
R289 PAD.n29 PAD.n28 0.141125
R290 PAD.n162 PAD.n161 0.141125
R291 PAD.n34 PAD.n33 0.141125
R292 PAD.n157 PAD.n156 0.141125
R293 PAD.n37 PAD.n36 0.141125
R294 PAD.n150 PAD.n149 0.141125
R295 PAD.n42 PAD.n41 0.141125
R296 PAD.n145 PAD.n144 0.141125
R297 PAD.n45 PAD.n44 0.141125
R298 PAD.n138 PAD.n137 0.141125
R299 PAD.n50 PAD.n49 0.141125
R300 PAD.n133 PAD.n132 0.141125
R301 PAD.n53 PAD.n52 0.141125
R302 PAD.n126 PAD.n125 0.141125
R303 PAD.n58 PAD.n57 0.141125
R304 PAD.n121 PAD.n120 0.141125
R305 PAD.n61 PAD.n60 0.141125
R306 PAD.n114 PAD.n113 0.141125
R307 PAD.n113 PAD.n112 0.141125
R308 PAD.n60 PAD.n59 0.141125
R309 PAD.n122 PAD.n121 0.141125
R310 PAD.n123 PAD.n58 0.141125
R311 PAD.n125 PAD.n124 0.141125
R312 PAD.n52 PAD.n51 0.141125
R313 PAD.n134 PAD.n133 0.141125
R314 PAD.n135 PAD.n50 0.141125
R315 PAD.n137 PAD.n136 0.141125
R316 PAD.n44 PAD.n43 0.141125
R317 PAD.n146 PAD.n145 0.141125
R318 PAD.n147 PAD.n42 0.141125
R319 PAD.n149 PAD.n148 0.141125
R320 PAD.n36 PAD.n35 0.141125
R321 PAD.n158 PAD.n157 0.141125
R322 PAD.n159 PAD.n34 0.141125
R323 PAD.n161 PAD.n160 0.141125
R324 PAD.n28 PAD.n27 0.141125
R325 PAD.n170 PAD.n169 0.141125
R326 PAD.n171 PAD.n26 0.141125
R327 PAD.n173 PAD.n172 0.141125
R328 PAD.n20 PAD.n19 0.141125
R329 PAD.n182 PAD.n181 0.141125
R330 PAD.n183 PAD.n17 0.141125
R331 PAD.n185 PAD.n184 0.141125
R332 PAD.n9 PAD.n8 0.141125
R333 PAD.n194 PAD.n193 0.141125
R334 PAD.n195 PAD.n7 0.141125
R335 PAD.n197 PAD.n196 0.141125
R336 PAD.n1 PAD.n0 0.141125
R337 PAD.n204 PAD.n203 0.141125
R338 PAD.n3 PAD.n2 0.141125
R339 PAD.n199 PAD.n198 0.141125
R340 PAD.n6 PAD.n5 0.141125
R341 PAD.n192 PAD.n191 0.141125
R342 PAD.n11 PAD.n10 0.141125
R343 PAD.n187 PAD.n186 0.141125
R344 PAD.n14 PAD.n13 0.141125
R345 PAD.n180 PAD.n179 0.141125
R346 PAD.n22 PAD.n21 0.141125
R347 PAD.n175 PAD.n174 0.141125
R348 PAD.n25 PAD.n24 0.141125
R349 PAD.n168 PAD.n167 0.141125
R350 PAD.n30 PAD.n29 0.141125
R351 PAD.n163 PAD.n162 0.141125
R352 PAD.n33 PAD.n32 0.141125
R353 PAD.n156 PAD.n155 0.141125
R354 PAD.n38 PAD.n37 0.141125
R355 PAD.n151 PAD.n150 0.141125
R356 PAD.n41 PAD.n40 0.141125
R357 PAD.n144 PAD.n143 0.141125
R358 PAD.n46 PAD.n45 0.141125
R359 PAD.n139 PAD.n138 0.141125
R360 PAD.n49 PAD.n48 0.141125
R361 PAD.n132 PAD.n131 0.141125
R362 PAD.n54 PAD.n53 0.141125
R363 PAD.n127 PAD.n126 0.141125
R364 PAD.n57 PAD.n56 0.141125
R365 PAD.n120 PAD.n119 0.141125
R366 PAD.n62 PAD.n61 0.141125
R367 PAD.n115 PAD.n114 0.141125
R368 PAD.n200 PAD.n199 0.141125
R369 PAD.n5 PAD.n4 0.141125
R370 PAD.n191 PAD.n190 0.141125
R371 PAD.n189 PAD.n11 0.141125
R372 PAD.n188 PAD.n187 0.141125
R373 PAD.n13 PAD.n12 0.141125
R374 PAD.n179 PAD.n178 0.141125
R375 PAD.n177 PAD.n22 0.141125
R376 PAD.n176 PAD.n175 0.141125
R377 PAD.n24 PAD.n23 0.141125
R378 PAD.n167 PAD.n166 0.141125
R379 PAD.n165 PAD.n30 0.141125
R380 PAD.n164 PAD.n163 0.141125
R381 PAD.n32 PAD.n31 0.141125
R382 PAD.n155 PAD.n154 0.141125
R383 PAD.n153 PAD.n38 0.141125
R384 PAD.n152 PAD.n151 0.141125
R385 PAD.n40 PAD.n39 0.141125
R386 PAD.n143 PAD.n142 0.141125
R387 PAD.n141 PAD.n46 0.141125
R388 PAD.n140 PAD.n139 0.141125
R389 PAD.n48 PAD.n47 0.141125
R390 PAD.n131 PAD.n130 0.141125
R391 PAD.n129 PAD.n54 0.141125
R392 PAD.n128 PAD.n127 0.141125
R393 PAD.n56 PAD.n55 0.141125
R394 PAD.n119 PAD.n118 0.141125
R395 PAD.n117 PAD.n62 0.141125
R396 PAD.n112 PAD.n111 0.140157
R397 PAD.n106 PAD.n105 0.12425
R398 PAD.n201 PAD.n200 0.0721774
R399 PAD.n117 PAD.n116 0.0721774
R400 PAD.n79 PAD.n69 0.05675
R401 PAD.n77 PAD.n76 0.03425
R402 PAD PAD.t43 0.0251094
R403 PAD PAD.t44 0.0251094
R404 PAD PAD.t45 0.0208125
R405 PAD.n203 PAD.n1 0.0033125
R406 PAD.n197 PAD.n1 0.0033125
R407 PAD.n197 PAD.n7 0.0033125
R408 PAD.n193 PAD.n7 0.0033125
R409 PAD.n193 PAD.n9 0.0033125
R410 PAD.n185 PAD.n17 0.0033125
R411 PAD.n181 PAD.n17 0.0033125
R412 PAD.n181 PAD.n20 0.0033125
R413 PAD.n173 PAD.n20 0.0033125
R414 PAD.n173 PAD.n26 0.0033125
R415 PAD.n169 PAD.n26 0.0033125
R416 PAD.n169 PAD.n28 0.0033125
R417 PAD.n161 PAD.n28 0.0033125
R418 PAD.n161 PAD.n34 0.0033125
R419 PAD.n157 PAD.n34 0.0033125
R420 PAD.n157 PAD.n36 0.0033125
R421 PAD.n149 PAD.n36 0.0033125
R422 PAD.n149 PAD.n42 0.0033125
R423 PAD.n145 PAD.n42 0.0033125
R424 PAD.n145 PAD.n44 0.0033125
R425 PAD.n137 PAD.n44 0.0033125
R426 PAD.n137 PAD.n50 0.0033125
R427 PAD.n133 PAD.n50 0.0033125
R428 PAD.n133 PAD.n52 0.0033125
R429 PAD.n125 PAD.n52 0.0033125
R430 PAD.n125 PAD.n58 0.0033125
R431 PAD.n121 PAD.n58 0.0033125
R432 PAD.n121 PAD.n60 0.0033125
R433 PAD.n113 PAD.n60 0.0033125
R434 PAD.n113 PAD.n110 0.0033125
R435 PAD.n204 PAD.n0 0.0033125
R436 PAD.n196 PAD.n0 0.0033125
R437 PAD.n196 PAD.n195 0.0033125
R438 PAD.n195 PAD.n194 0.0033125
R439 PAD.n194 PAD.n8 0.0033125
R440 PAD.n184 PAD.n8 0.0033125
R441 PAD.n184 PAD.n183 0.0033125
R442 PAD.n183 PAD.n182 0.0033125
R443 PAD.n182 PAD.n19 0.0033125
R444 PAD.n172 PAD.n19 0.0033125
R445 PAD.n172 PAD.n171 0.0033125
R446 PAD.n171 PAD.n170 0.0033125
R447 PAD.n170 PAD.n27 0.0033125
R448 PAD.n160 PAD.n27 0.0033125
R449 PAD.n160 PAD.n159 0.0033125
R450 PAD.n159 PAD.n158 0.0033125
R451 PAD.n158 PAD.n35 0.0033125
R452 PAD.n148 PAD.n35 0.0033125
R453 PAD.n148 PAD.n147 0.0033125
R454 PAD.n147 PAD.n146 0.0033125
R455 PAD.n146 PAD.n43 0.0033125
R456 PAD.n136 PAD.n43 0.0033125
R457 PAD.n136 PAD.n135 0.0033125
R458 PAD.n135 PAD.n134 0.0033125
R459 PAD.n134 PAD.n51 0.0033125
R460 PAD.n124 PAD.n51 0.0033125
R461 PAD.n124 PAD.n123 0.0033125
R462 PAD.n123 PAD.n122 0.0033125
R463 PAD.n122 PAD.n59 0.0033125
R464 PAD.n112 PAD.n59 0.0033125
R465 PAD.n202 PAD.n2 0.0033125
R466 PAD.n198 PAD.n2 0.0033125
R467 PAD.n198 PAD.n6 0.0033125
R468 PAD.n192 PAD.n6 0.0033125
R469 PAD.n192 PAD.n10 0.0033125
R470 PAD.n186 PAD.n14 0.0033125
R471 PAD.n180 PAD.n14 0.0033125
R472 PAD.n180 PAD.n21 0.0033125
R473 PAD.n174 PAD.n21 0.0033125
R474 PAD.n174 PAD.n25 0.0033125
R475 PAD.n168 PAD.n25 0.0033125
R476 PAD.n168 PAD.n29 0.0033125
R477 PAD.n162 PAD.n29 0.0033125
R478 PAD.n162 PAD.n33 0.0033125
R479 PAD.n156 PAD.n33 0.0033125
R480 PAD.n156 PAD.n37 0.0033125
R481 PAD.n150 PAD.n37 0.0033125
R482 PAD.n150 PAD.n41 0.0033125
R483 PAD.n144 PAD.n41 0.0033125
R484 PAD.n144 PAD.n45 0.0033125
R485 PAD.n138 PAD.n45 0.0033125
R486 PAD.n138 PAD.n49 0.0033125
R487 PAD.n132 PAD.n49 0.0033125
R488 PAD.n132 PAD.n53 0.0033125
R489 PAD.n126 PAD.n53 0.0033125
R490 PAD.n126 PAD.n57 0.0033125
R491 PAD.n120 PAD.n57 0.0033125
R492 PAD.n120 PAD.n61 0.0033125
R493 PAD.n114 PAD.n61 0.0033125
R494 PAD.n114 PAD.n109 0.0033125
R495 PAD.n199 PAD.n3 0.0033125
R496 PAD.n199 PAD.n5 0.0033125
R497 PAD.n191 PAD.n5 0.0033125
R498 PAD.n191 PAD.n11 0.0033125
R499 PAD.n187 PAD.n11 0.0033125
R500 PAD.n187 PAD.n13 0.0033125
R501 PAD.n179 PAD.n13 0.0033125
R502 PAD.n179 PAD.n22 0.0033125
R503 PAD.n175 PAD.n22 0.0033125
R504 PAD.n175 PAD.n24 0.0033125
R505 PAD.n167 PAD.n24 0.0033125
R506 PAD.n167 PAD.n30 0.0033125
R507 PAD.n163 PAD.n30 0.0033125
R508 PAD.n163 PAD.n32 0.0033125
R509 PAD.n155 PAD.n32 0.0033125
R510 PAD.n155 PAD.n38 0.0033125
R511 PAD.n151 PAD.n38 0.0033125
R512 PAD.n151 PAD.n40 0.0033125
R513 PAD.n143 PAD.n40 0.0033125
R514 PAD.n143 PAD.n46 0.0033125
R515 PAD.n139 PAD.n46 0.0033125
R516 PAD.n139 PAD.n48 0.0033125
R517 PAD.n131 PAD.n48 0.0033125
R518 PAD.n131 PAD.n54 0.0033125
R519 PAD.n127 PAD.n54 0.0033125
R520 PAD.n127 PAD.n56 0.0033125
R521 PAD.n119 PAD.n56 0.0033125
R522 PAD.n119 PAD.n62 0.0033125
R523 PAD.n115 PAD.n62 0.0033125
R524 PAD.n18 PAD.n9 0.00256719
R525 PAD.n16 PAD.n10 0.00256719
R526 PAD.n201 PAD.n3 0.00238623
R527 PAD.n116 PAD.n115 0.00238623
R528 PAD.n200 PAD.n4 0.00175
R529 PAD.n190 PAD.n4 0.00175
R530 PAD.n190 PAD.n189 0.00175
R531 PAD.n189 PAD.n188 0.00175
R532 PAD.n188 PAD.n12 0.00175
R533 PAD.n178 PAD.n12 0.00175
R534 PAD.n178 PAD.n177 0.00175
R535 PAD.n177 PAD.n176 0.00175
R536 PAD.n176 PAD.n23 0.00175
R537 PAD.n166 PAD.n23 0.00175
R538 PAD.n166 PAD.n165 0.00175
R539 PAD.n165 PAD.n164 0.00175
R540 PAD.n164 PAD.n31 0.00175
R541 PAD.n154 PAD.n31 0.00175
R542 PAD.n154 PAD.n153 0.00175
R543 PAD.n153 PAD.n152 0.00175
R544 PAD.n152 PAD.n39 0.00175
R545 PAD.n142 PAD.n39 0.00175
R546 PAD.n142 PAD.n141 0.00175
R547 PAD.n141 PAD.n140 0.00175
R548 PAD.n140 PAD.n47 0.00175
R549 PAD.n130 PAD.n47 0.00175
R550 PAD.n130 PAD.n129 0.00175
R551 PAD.n129 PAD.n128 0.00175
R552 PAD.n128 PAD.n55 0.00175
R553 PAD.n118 PAD.n55 0.00175
R554 PAD.n118 PAD.n117 0.00175
R555 PAD.n185 PAD.n18 0.00124531
R556 PAD.n205 PAD.n204 0.00124531
R557 PAD.n186 PAD.n16 0.00124531
R558 PAD.n111 PAD.n110 0.00102002
R559 VDDIO VDDIO.t5 526.747
R560 VDDIO VDDIO.t102 521.779
R561 VDDIO.n42 VDDIO.t9 395.611
R562 VDDIO.n43 VDDIO.t3 395.503
R563 VDDIO.n45 VDDIO.t98 395.503
R564 VDDIO.n47 VDDIO.t16 395.503
R565 VDDIO.n41 VDDIO.t0 395.503
R566 VDDIO.n39 VDDIO.t2 395.503
R567 VDDIO.n38 VDDIO.t12 395.503
R568 VDDIO.n36 VDDIO.t100 395.503
R569 VDDIO.n34 VDDIO.t106 395.503
R570 VDDIO.n32 VDDIO.t104 395.503
R571 VDDIO.n30 VDDIO.t11 395.503
R572 VDDIO.n29 VDDIO.t108 395.503
R573 VDDIO.n27 VDDIO.t14 395.503
R574 VDDIO.n66 VDDIO.t7 232.214
R575 VDDIO.n0 VDDIO.t18 192.674
R576 VDDIO.t18 VDDIO.t20 136.519
R577 VDDIO.t20 VDDIO.t24 136.519
R578 VDDIO.t24 VDDIO.t22 136.519
R579 VDDIO.t22 VDDIO.t26 136.519
R580 VDDIO.t26 VDDIO.t28 136.519
R581 VDDIO.t28 VDDIO.t30 136.519
R582 VDDIO.t30 VDDIO.t32 136.519
R583 VDDIO.t32 VDDIO.t34 136.519
R584 VDDIO.t34 VDDIO.t38 136.519
R585 VDDIO.t38 VDDIO.t40 136.519
R586 VDDIO.t40 VDDIO.t36 136.519
R587 VDDIO.t36 VDDIO.t42 136.519
R588 VDDIO.t42 VDDIO.t44 136.519
R589 VDDIO.t44 VDDIO.t46 136.519
R590 VDDIO.t46 VDDIO.t48 136.519
R591 VDDIO.t48 VDDIO.t52 136.519
R592 VDDIO.t52 VDDIO.t50 136.519
R593 VDDIO.t50 VDDIO.t54 136.519
R594 VDDIO.t54 VDDIO.t56 136.519
R595 VDDIO.t56 VDDIO.t64 136.519
R596 VDDIO.t64 VDDIO.t58 136.519
R597 VDDIO.t58 VDDIO.t60 136.519
R598 VDDIO.t60 VDDIO.t66 136.519
R599 VDDIO.t66 VDDIO.t68 136.519
R600 VDDIO.t68 VDDIO.t72 136.519
R601 VDDIO.t72 VDDIO.t78 136.519
R602 VDDIO.t78 VDDIO.t76 136.519
R603 VDDIO.t76 VDDIO.t74 136.519
R604 VDDIO.t74 VDDIO.t70 136.519
R605 VDDIO.t70 VDDIO.t80 136.519
R606 VDDIO.t80 VDDIO.t82 136.519
R607 VDDIO.t82 VDDIO.t84 136.519
R608 VDDIO.t84 VDDIO.t90 136.519
R609 VDDIO.t90 VDDIO.t88 136.519
R610 VDDIO.t88 VDDIO.t86 136.519
R611 VDDIO.t86 VDDIO.t62 136.519
R612 VDDIO.t62 VDDIO.t92 136.519
R613 VDDIO.t92 VDDIO.t94 136.519
R614 VDDIO.t94 VDDIO.t96 136.519
R615 VDDIO.n50 VDDIO.n49 14.0765
R616 VDDIO.n64 VDDIO.n63 10.7074
R617 VDDIO.n65 VDDIO.n64 8.4605
R618 VDDIO.n20 VDDIO.t97 7.27651
R619 VDDIO.n20 VDDIO.n19 6.55251
R620 VDDIO.n21 VDDIO.n18 6.55251
R621 VDDIO.n22 VDDIO.n17 6.55251
R622 VDDIO.n23 VDDIO.n16 6.55251
R623 VDDIO.n24 VDDIO.n15 6.55251
R624 VDDIO.n25 VDDIO.n14 6.55251
R625 VDDIO.n26 VDDIO.n13 6.55251
R626 VDDIO.n51 VDDIO.n12 6.55251
R627 VDDIO.n52 VDDIO.n11 6.55251
R628 VDDIO.n53 VDDIO.n10 6.55251
R629 VDDIO.n54 VDDIO.n9 6.55251
R630 VDDIO.n55 VDDIO.n8 6.55251
R631 VDDIO.n56 VDDIO.n7 6.55251
R632 VDDIO.n57 VDDIO.n6 6.55251
R633 VDDIO.n58 VDDIO.n5 6.55251
R634 VDDIO.n59 VDDIO.n4 6.55251
R635 VDDIO.n60 VDDIO.n3 6.55251
R636 VDDIO.n61 VDDIO.n2 6.55251
R637 VDDIO.n62 VDDIO.n1 6.55251
R638 VDDIO.n63 VDDIO.n0 5.80076
R639 VDDIO VDDIO.n66 5.58476
R640 VDDIO.n64 VDDIO 4.9355
R641 VDDIO.n65 VDDIO 4.9355
R642 VDDIO.n27 VDDIO.t15 3.0835
R643 VDDIO.n42 VDDIO.t10 2.9755
R644 VDDIO.n44 VDDIO.t4 2.9755
R645 VDDIO.n46 VDDIO.t99 2.9755
R646 VDDIO.n48 VDDIO.t17 2.9755
R647 VDDIO.n40 VDDIO.t1 2.9755
R648 VDDIO.n37 VDDIO.t13 2.9755
R649 VDDIO.n35 VDDIO.t101 2.9755
R650 VDDIO.n33 VDDIO.t107 2.9755
R651 VDDIO.n31 VDDIO.t105 2.9755
R652 VDDIO.n28 VDDIO.t109 2.9755
R653 VDDIO.n66 VDDIO.t8 1.21208
R654 VDDIO.n0 VDDIO.t19 1.1095
R655 VDDIO VDDIO.n65 1.0805
R656 VDDIO.n39 VDDIO.n38 0.5855
R657 VDDIO.n30 VDDIO.n29 0.5855
R658 VDDIO.n43 VDDIO.n42 0.4925
R659 VDDIO.n45 VDDIO.n44 0.4925
R660 VDDIO.n37 VDDIO.n36 0.4925
R661 VDDIO.n35 VDDIO.n34 0.4925
R662 VDDIO.n33 VDDIO.n32 0.4925
R663 VDDIO.n28 VDDIO.n27 0.4925
R664 VDDIO.n49 VDDIO.n41 0.4325
R665 VDDIO.n19 VDDIO.t93 0.3645
R666 VDDIO.n19 VDDIO.t95 0.3645
R667 VDDIO.n18 VDDIO.t87 0.3645
R668 VDDIO.n18 VDDIO.t63 0.3645
R669 VDDIO.n17 VDDIO.t91 0.3645
R670 VDDIO.n17 VDDIO.t89 0.3645
R671 VDDIO.n16 VDDIO.t83 0.3645
R672 VDDIO.n16 VDDIO.t85 0.3645
R673 VDDIO.n15 VDDIO.t71 0.3645
R674 VDDIO.n15 VDDIO.t81 0.3645
R675 VDDIO.n14 VDDIO.t77 0.3645
R676 VDDIO.n14 VDDIO.t75 0.3645
R677 VDDIO.n13 VDDIO.t73 0.3645
R678 VDDIO.n13 VDDIO.t79 0.3645
R679 VDDIO.n12 VDDIO.t67 0.3645
R680 VDDIO.n12 VDDIO.t69 0.3645
R681 VDDIO.n11 VDDIO.t59 0.3645
R682 VDDIO.n11 VDDIO.t61 0.3645
R683 VDDIO.n10 VDDIO.t57 0.3645
R684 VDDIO.n10 VDDIO.t65 0.3645
R685 VDDIO.n9 VDDIO.t51 0.3645
R686 VDDIO.n9 VDDIO.t55 0.3645
R687 VDDIO.n8 VDDIO.t49 0.3645
R688 VDDIO.n8 VDDIO.t53 0.3645
R689 VDDIO.n7 VDDIO.t45 0.3645
R690 VDDIO.n7 VDDIO.t47 0.3645
R691 VDDIO.n6 VDDIO.t37 0.3645
R692 VDDIO.n6 VDDIO.t43 0.3645
R693 VDDIO.n5 VDDIO.t39 0.3645
R694 VDDIO.n5 VDDIO.t41 0.3645
R695 VDDIO.n4 VDDIO.t33 0.3645
R696 VDDIO.n4 VDDIO.t35 0.3645
R697 VDDIO.n3 VDDIO.t29 0.3645
R698 VDDIO.n3 VDDIO.t31 0.3645
R699 VDDIO.n2 VDDIO.t23 0.3645
R700 VDDIO.n2 VDDIO.t27 0.3645
R701 VDDIO.n1 VDDIO.t21 0.3645
R702 VDDIO.n1 VDDIO.t25 0.3645
R703 VDDIO.n62 VDDIO.n61 0.3605
R704 VDDIO.n61 VDDIO.n60 0.3605
R705 VDDIO.n60 VDDIO.n59 0.3605
R706 VDDIO.n59 VDDIO.n58 0.3605
R707 VDDIO.n58 VDDIO.n57 0.3605
R708 VDDIO.n57 VDDIO.n56 0.3605
R709 VDDIO.n56 VDDIO.n55 0.3605
R710 VDDIO.n55 VDDIO.n54 0.3605
R711 VDDIO.n54 VDDIO.n53 0.3605
R712 VDDIO.n53 VDDIO.n52 0.3605
R713 VDDIO.n52 VDDIO.n51 0.3605
R714 VDDIO.n26 VDDIO.n25 0.3605
R715 VDDIO.n25 VDDIO.n24 0.3605
R716 VDDIO.n24 VDDIO.n23 0.3605
R717 VDDIO.n23 VDDIO.n22 0.3605
R718 VDDIO.n22 VDDIO.n21 0.3605
R719 VDDIO.n21 VDDIO.n20 0.3605
R720 VDDIO.n47 VDDIO.n46 0.3575
R721 VDDIO.n40 VDDIO.n39 0.3575
R722 VDDIO.n31 VDDIO.n30 0.3575
R723 VDDIO VDDIO.n62 0.345535
R724 VDDIO.n50 VDDIO.n26 0.221
R725 VDDIO.n51 VDDIO.n50 0.14
R726 VDDIO.n44 VDDIO.n43 0.1085
R727 VDDIO.n46 VDDIO.n45 0.1085
R728 VDDIO.n48 VDDIO.n47 0.1085
R729 VDDIO.n41 VDDIO.n40 0.1085
R730 VDDIO.n38 VDDIO.n37 0.1085
R731 VDDIO.n36 VDDIO.n35 0.1085
R732 VDDIO.n34 VDDIO.n33 0.1085
R733 VDDIO.n32 VDDIO.n31 0.1085
R734 VDDIO.n29 VDDIO.n28 0.1085
R735 VDDIO.n49 VDDIO.n48 0.0455
R736 VDDIO.n63 VDDIO 0.00259302
R737 VSSIO.n194 VSSIO.n191 23902.5
R738 VSSIO.n49 VSSIO.n48 14754
R739 VSSIO.n183 VSSIO.n9 14754
R740 VSSIO.n185 VSSIO.n7 14754
R741 VSSIO.n191 VSSIO.t130 7139.79
R742 VSSIO.n161 VSSIO.n45 6500
R743 VSSIO.n182 VSSIO.n10 6500
R744 VSSIO.n184 VSSIO.n8 6500
R745 VSSIO.n187 VSSIO.n5 6075.16
R746 VSSIO.n180 VSSIO.n12 6075.16
R747 VSSIO.n164 VSSIO.n44 6075.16
R748 VSSIO.n51 VSSIO.n47 6075.16
R749 VSSIO.n186 VSSIO.n6 6075.16
R750 VSSIO.n181 VSSIO.n11 5957.57
R751 VSSIO.n188 VSSIO.n187 3320.47
R752 VSSIO.n187 VSSIO.n186 2863.44
R753 VSSIO.n182 VSSIO.n181 2747.36
R754 VSSIO.n186 VSSIO.n185 2541.3
R755 VSSIO.n185 VSSIO.n184 2505.51
R756 VSSIO.n184 VSSIO.n183 2505.51
R757 VSSIO.n183 VSSIO.n182 2505.51
R758 VSSIO.n188 VSSIO.n4 2246.95
R759 VSSIO.n194 VSSIO.n189 2026.43
R760 VSSIO.n189 VSSIO.n188 1929.11
R761 VSSIO.n193 VSSIO.n191 1816.21
R762 VSSIO.t130 VSSIO.n190 1721.23
R763 VSSIO.n181 VSSIO.n180 1323.82
R764 VSSIO.n194 VSSIO.t132 1089.29
R765 VSSIO.n180 VSSIO.n179 839.062
R766 VSSIO.n195 VSSIO.n194 822.636
R767 VSSIO.n196 VSSIO.n195 700.774
R768 VSSIO.n190 VSSIO.t128 439.973
R769 VSSIO.n179 VSSIO.t148 350
R770 VSSIO.t152 VSSIO.t150 250
R771 VSSIO.t156 VSSIO.t152 250
R772 VSSIO.t160 VSSIO.t156 250
R773 VSSIO.t162 VSSIO.t158 250
R774 VSSIO.t158 VSSIO.t154 250
R775 VSSIO.t154 VSSIO.t164 250
R776 VSSIO.t164 VSSIO.t166 250
R777 VSSIO.t168 VSSIO.t170 250
R778 VSSIO.t170 VSSIO.t172 250
R779 VSSIO.t172 VSSIO.t174 250
R780 VSSIO.t176 VSSIO.t182 250
R781 VSSIO.t182 VSSIO.t178 250
R782 VSSIO.t178 VSSIO.t186 250
R783 VSSIO.t186 VSSIO.t180 250
R784 VSSIO.t180 VSSIO.t188 250
R785 VSSIO.t188 VSSIO.t190 250
R786 VSSIO.t190 VSSIO.t192 250
R787 VSSIO.t192 VSSIO.t200 250
R788 VSSIO.t204 VSSIO.t196 250
R789 VSSIO.t202 VSSIO.t204 250
R790 VSSIO.t194 VSSIO.t202 250
R791 VSSIO.t198 VSSIO.t194 250
R792 VSSIO.t206 VSSIO.t198 250
R793 VSSIO.t184 VSSIO.t206 250
R794 VSSIO.t208 VSSIO.t184 250
R795 VSSIO.t210 VSSIO.t208 250
R796 VSSIO.t212 VSSIO.t210 250
R797 VSSIO.t214 VSSIO.t212 250
R798 VSSIO.t216 VSSIO.t214 250
R799 VSSIO.t218 VSSIO.t216 250
R800 VSSIO.t220 VSSIO.t218 250
R801 VSSIO.t224 VSSIO.t222 250
R802 VSSIO.t222 VSSIO.t226 250
R803 VSSIO.t174 VSSIO.n44 248.439
R804 VSSIO.n45 VSSIO.t168 235.939
R805 VSSIO.n195 VSSIO.t200 223.439
R806 VSSIO.n5 VSSIO.t134 202.626
R807 VSSIO.t126 VSSIO.n6 202.626
R808 VSSIO.t230 VSSIO.n12 202.626
R809 VSSIO.t2 VSSIO.n11 202.321
R810 VSSIO.n143 VSSIO.n8 201.484
R811 VSSIO.t140 VSSIO.n10 196.918
R812 VSSIO.n43 VSSIO.t220 195.312
R813 VSSIO.t150 VSSIO.n47 189.062
R814 VSSIO.n48 VSSIO.t160 170.312
R815 VSSIO.n145 VSSIO.n7 155.822
R816 VSSIO.t0 VSSIO.n9 151.256
R817 VSSIO.t134 VSSIO.n4 127.855
R818 VSSIO.n146 VSSIO.t126 127.855
R819 VSSIO.n145 VSSIO.t228 127.855
R820 VSSIO.n143 VSSIO.t144 127.855
R821 VSSIO.n141 VSSIO.t0 127.855
R822 VSSIO.n139 VSSIO.t140 127.855
R823 VSSIO.n137 VSSIO.t2 127.855
R824 VSSIO.n135 VSSIO.t230 127.855
R825 VSSIO.n133 VSSIO.t142 127.855
R826 VSSIO.n132 VSSIO.t7 127.855
R827 VSSIO.n146 VSSIO.n5 126.142
R828 VSSIO.n133 VSSIO.n12 126.142
R829 VSSIO.n135 VSSIO.n11 125.825
R830 VSSIO.t228 VSSIO.n6 121.576
R831 VSSIO.t132 VSSIO.n193 121.334
R832 VSSIO.n141 VSSIO.n8 120.434
R833 VSSIO.n137 VSSIO.n10 120.434
R834 VSSIO.n196 VSSIO.t229 101.365
R835 VSSIO.t13 VSSIO.t16 91.3247
R836 VSSIO.t31 VSSIO.t28 91.3247
R837 VSSIO.t34 VSSIO.t31 91.3247
R838 VSSIO.t46 VSSIO.t43 91.3247
R839 VSSIO.t52 VSSIO.t49 91.3247
R840 VSSIO.t58 VSSIO.t61 91.3247
R841 VSSIO.n164 VSSIO.t46 90.7539
R842 VSSIO.t4 VSSIO.t19 89.0416
R843 VSSIO.t37 VSSIO.n161 86.1877
R844 VSSIO.t61 VSSIO.t64 83.3007
R845 VSSIO.t64 VSSIO.t67 82.9881
R846 VSSIO.t67 VSSIO.t70 82.9881
R847 VSSIO.t70 VSSIO.t73 82.9881
R848 VSSIO.t73 VSSIO.t76 82.9881
R849 VSSIO.t76 VSSIO.t79 82.9881
R850 VSSIO.t79 VSSIO.t82 82.9881
R851 VSSIO.t82 VSSIO.t85 82.9881
R852 VSSIO.t85 VSSIO.t88 82.9881
R853 VSSIO.t88 VSSIO.t91 82.9881
R854 VSSIO.t91 VSSIO.t94 82.9881
R855 VSSIO.t94 VSSIO.t97 82.9881
R856 VSSIO.t97 VSSIO.t100 82.9881
R857 VSSIO.t100 VSSIO.t103 82.9881
R858 VSSIO.t103 VSSIO.t106 82.9881
R859 VSSIO.t106 VSSIO.t109 82.9881
R860 VSSIO.t109 VSSIO.t112 82.9881
R861 VSSIO.t112 VSSIO.t115 82.9881
R862 VSSIO.t118 VSSIO.t121 82.9881
R863 VSSIO.t121 VSSIO.t124 82.9881
R864 VSSIO.t136 VSSIO.t25 82.1923
R865 VSSIO.n48 VSSIO.t162 79.688
R866 VSSIO.n139 VSSIO.n9 74.7722
R867 VSSIO.t138 VSSIO.t40 70.7768
R868 VSSIO.t55 VSSIO.t146 70.7768
R869 VSSIO.n91 VSSIO.t123 70.3412
R870 VSSIO.t144 VSSIO.n7 70.206
R871 VSSIO.n51 VSSIO.t10 69.0644
R872 VSSIO.t115 VSSIO.n43 64.8345
R873 VSSIO.t19 VSSIO.n49 62.2151
R874 VSSIO.n47 VSSIO.t148 60.938
R875 VSSIO.n190 VSSIO.n189 59.7698
R876 VSSIO.n91 VSSIO.t120 58.6612
R877 VSSIO.n92 VSSIO.t117 58.6612
R878 VSSIO.n93 VSSIO.t114 58.6612
R879 VSSIO.n94 VSSIO.t111 58.6612
R880 VSSIO.n95 VSSIO.t108 58.6612
R881 VSSIO.n96 VSSIO.t105 58.6612
R882 VSSIO.n97 VSSIO.t102 58.6612
R883 VSSIO.n98 VSSIO.t99 58.6612
R884 VSSIO.n99 VSSIO.t96 58.6612
R885 VSSIO.n100 VSSIO.t93 58.6612
R886 VSSIO.n101 VSSIO.t90 58.6612
R887 VSSIO.n102 VSSIO.t87 58.6612
R888 VSSIO.n103 VSSIO.t84 58.6612
R889 VSSIO.n104 VSSIO.t81 58.6612
R890 VSSIO.n105 VSSIO.t78 58.6612
R891 VSSIO.n106 VSSIO.t75 58.6612
R892 VSSIO.n107 VSSIO.t72 58.6612
R893 VSSIO.n108 VSSIO.t69 58.6612
R894 VSSIO.n109 VSSIO.t66 58.6612
R895 VSSIO.n110 VSSIO.t63 58.6612
R896 VSSIO.n111 VSSIO.t60 58.6612
R897 VSSIO.n112 VSSIO.t57 58.6612
R898 VSSIO.n113 VSSIO.t54 58.6612
R899 VSSIO.n114 VSSIO.t51 58.6612
R900 VSSIO.n115 VSSIO.t48 58.6612
R901 VSSIO.n116 VSSIO.t45 58.6612
R902 VSSIO.n117 VSSIO.t42 58.6612
R903 VSSIO.n118 VSSIO.t39 58.6612
R904 VSSIO.n119 VSSIO.t36 58.6612
R905 VSSIO.n120 VSSIO.t33 58.6612
R906 VSSIO.n121 VSSIO.t30 58.6612
R907 VSSIO.n122 VSSIO.t27 58.6612
R908 VSSIO.n123 VSSIO.t24 58.6612
R909 VSSIO.n124 VSSIO.t21 58.6612
R910 VSSIO.n125 VSSIO.t18 58.6612
R911 VSSIO.n126 VSSIO.t15 58.6612
R912 VSSIO.n127 VSSIO.t12 58.6612
R913 VSSIO.n128 VSSIO.t9 58.6612
R914 VSSIO.n129 VSSIO.t6 58.6612
R915 VSSIO.t10 VSSIO.n50 57.0781
R916 VSSIO.t40 VSSIO.n163 57.0781
R917 VSSIO.n165 VSSIO.t55 57.0781
R918 VSSIO.n43 VSSIO.t224 54.688
R919 VSSIO.t142 VSSIO.n132 52.5119
R920 VSSIO.n160 VSSIO.t22 45.6626
R921 VSSIO.t25 VSSIO.n160 45.6626
R922 VSSIO.n130 VSSIO.n129 43.42
R923 VSSIO.n50 VSSIO.t13 34.2471
R924 VSSIO.n163 VSSIO.t37 34.2471
R925 VSSIO.n165 VSSIO.t52 34.2471
R926 VSSIO.n198 VSSIO.n197 33.233
R927 VSSIO.n49 VSSIO.t22 29.1101
R928 VSSIO.n195 VSSIO.t196 26.563
R929 VSSIO.t7 VSSIO.n51 22.2608
R930 VSSIO.t43 VSSIO.t138 20.5484
R931 VSSIO.t146 VSSIO.t58 20.5484
R932 VSSIO.n43 VSSIO.t118 18.154
R933 VSSIO.n168 VSSIO.n167 16.8827
R934 VSSIO.t166 VSSIO.n45 14.063
R935 VSSIO.n197 VSSIO.n3 13.595
R936 VSSIO.n198 VSSIO.n2 12.7831
R937 VSSIO.n197 VSSIO 12.4655
R938 VSSIO.n129 VSSIO.n128 11.6805
R939 VSSIO.n128 VSSIO.n127 11.6805
R940 VSSIO.n127 VSSIO.n126 11.6805
R941 VSSIO.n126 VSSIO.n125 11.6805
R942 VSSIO.n125 VSSIO.n124 11.6805
R943 VSSIO.n124 VSSIO.n123 11.6805
R944 VSSIO.n123 VSSIO.n122 11.6805
R945 VSSIO.n122 VSSIO.n121 11.6805
R946 VSSIO.n121 VSSIO.n120 11.6805
R947 VSSIO.n120 VSSIO.n119 11.6805
R948 VSSIO.n119 VSSIO.n118 11.6805
R949 VSSIO.n118 VSSIO.n117 11.6805
R950 VSSIO.n117 VSSIO.n116 11.6805
R951 VSSIO.n116 VSSIO.n115 11.6805
R952 VSSIO.n115 VSSIO.n114 11.6805
R953 VSSIO.n114 VSSIO.n113 11.6805
R954 VSSIO.n113 VSSIO.n112 11.6805
R955 VSSIO.n112 VSSIO.n111 11.6805
R956 VSSIO.n111 VSSIO.n110 11.6805
R957 VSSIO.n110 VSSIO.n109 11.6805
R958 VSSIO.n109 VSSIO.n108 11.6805
R959 VSSIO.n108 VSSIO.n107 11.6805
R960 VSSIO.n107 VSSIO.n106 11.6805
R961 VSSIO.n106 VSSIO.n105 11.6805
R962 VSSIO.n105 VSSIO.n104 11.6805
R963 VSSIO.n104 VSSIO.n103 11.6805
R964 VSSIO.n103 VSSIO.n102 11.6805
R965 VSSIO.n102 VSSIO.n101 11.6805
R966 VSSIO.n101 VSSIO.n100 11.6805
R967 VSSIO.n100 VSSIO.n99 11.6805
R968 VSSIO.n99 VSSIO.n98 11.6805
R969 VSSIO.n98 VSSIO.n97 11.6805
R970 VSSIO.n97 VSSIO.n96 11.6805
R971 VSSIO.n96 VSSIO.n95 11.6805
R972 VSSIO.n95 VSSIO.n94 11.6805
R973 VSSIO.n94 VSSIO.n93 11.6805
R974 VSSIO.n93 VSSIO.n92 11.6805
R975 VSSIO.n92 VSSIO.n91 11.6805
R976 VSSIO.n72 VSSIO 11.5725
R977 VSSIO.n1 VSSIO 9.2345
R978 VSSIO.t28 VSSIO.t136 9.13292
R979 VSSIO.n0 VSSIO 8.0555
R980 VSSIO.n3 VSSIO.t227 7.3895
R981 VSSIO.n71 VSSIO.t125 6.87816
R982 VSSIO.n32 VSSIO.n31 6.53225
R983 VSSIO.n33 VSSIO.n30 6.53225
R984 VSSIO.n34 VSSIO.n29 6.53225
R985 VSSIO.n35 VSSIO.n28 6.53225
R986 VSSIO.n36 VSSIO.n27 6.53225
R987 VSSIO.n37 VSSIO.n26 6.53225
R988 VSSIO.n38 VSSIO.n25 6.53225
R989 VSSIO.n39 VSSIO.n24 6.53225
R990 VSSIO.n40 VSSIO.n23 6.53225
R991 VSSIO.n41 VSSIO.n22 6.53225
R992 VSSIO.n169 VSSIO.n21 6.53225
R993 VSSIO.n170 VSSIO.n20 6.53225
R994 VSSIO.n171 VSSIO.n19 6.53225
R995 VSSIO.n172 VSSIO.n18 6.53225
R996 VSSIO.n173 VSSIO.n17 6.53225
R997 VSSIO.n174 VSSIO.n16 6.53225
R998 VSSIO.n175 VSSIO.n15 6.53225
R999 VSSIO.n176 VSSIO.n14 6.53225
R1000 VSSIO.n177 VSSIO.n13 6.53225
R1001 VSSIO.n71 VSSIO.n70 6.10866
R1002 VSSIO.n73 VSSIO.n69 6.10866
R1003 VSSIO.n74 VSSIO.n68 6.10866
R1004 VSSIO.n75 VSSIO.n67 6.10866
R1005 VSSIO.n76 VSSIO.n66 6.10866
R1006 VSSIO.n77 VSSIO.n65 6.10866
R1007 VSSIO.n78 VSSIO.n64 6.10866
R1008 VSSIO.n79 VSSIO.n63 6.10866
R1009 VSSIO.n80 VSSIO.n62 6.10866
R1010 VSSIO.n81 VSSIO.n61 6.10866
R1011 VSSIO.n82 VSSIO.n60 6.10866
R1012 VSSIO.n83 VSSIO.n59 6.10866
R1013 VSSIO.n84 VSSIO.n58 6.10866
R1014 VSSIO.n85 VSSIO.n57 6.10866
R1015 VSSIO.n86 VSSIO.n56 6.10866
R1016 VSSIO.n87 VSSIO.n55 6.10866
R1017 VSSIO.n88 VSSIO.n54 6.10866
R1018 VSSIO.n89 VSSIO.n53 6.10866
R1019 VSSIO.n90 VSSIO.n52 6.10866
R1020 VSSIO.n150 VSSIO.n145 5.66277
R1021 VSSIO.n0 VSSIO 5.5355
R1022 VSSIO.n131 VSSIO.n130 5.32116
R1023 VSSIO.n148 VSSIO.n4 5.2005
R1024 VSSIO.n147 VSSIO.n146 5.2005
R1025 VSSIO.n144 VSSIO.n143 5.2005
R1026 VSSIO.n142 VSSIO.n141 5.2005
R1027 VSSIO.n140 VSSIO.n139 5.2005
R1028 VSSIO.n138 VSSIO.n137 5.2005
R1029 VSSIO.n136 VSSIO.n135 5.2005
R1030 VSSIO.n134 VSSIO.n133 5.2005
R1031 VSSIO.n50 VSSIO.n46 5.2005
R1032 VSSIO.n160 VSSIO.n159 5.2005
R1033 VSSIO.n163 VSSIO.n162 5.2005
R1034 VSSIO.n166 VSSIO.n165 5.2005
R1035 VSSIO.n161 VSSIO.t34 5.13749
R1036 VSSIO.n192 VSSIO.n2 5.1222
R1037 VSSIO.n178 VSSIO 4.9595
R1038 VSSIO.n166 VSSIO.t147 4.901
R1039 VSSIO.n162 VSSIO.t139 4.901
R1040 VSSIO.n159 VSSIO.t137 4.901
R1041 VSSIO.n46 VSSIO.t5 4.901
R1042 VSSIO.n134 VSSIO.t143 4.901
R1043 VSSIO.n136 VSSIO.t231 4.901
R1044 VSSIO.n138 VSSIO.t3 4.901
R1045 VSSIO.n140 VSSIO.t141 4.901
R1046 VSSIO.n142 VSSIO.t1 4.901
R1047 VSSIO.n144 VSSIO.t145 4.901
R1048 VSSIO.n147 VSSIO.t127 4.901
R1049 VSSIO.n148 VSSIO.t135 4.901
R1050 VSSIO.n193 VSSIO.n192 2.93626
R1051 VSSIO.n179 VSSIO.n178 2.93626
R1052 VSSIO.n178 VSSIO.t149 2.3945
R1053 VSSIO.n192 VSSIO.t133 2.3945
R1054 VSSIO.n1 VSSIO.n0 2.3405
R1055 VSSIO.t16 VSSIO.t4 2.2836
R1056 VSSIO.n132 VSSIO.n131 1.59212
R1057 VSSIO.n44 VSSIO.t176 1.563
R1058 VSSIO VSSIO.n1 1.4405
R1059 VSSIO.n131 VSSIO.t8 1.1975
R1060 VSSIO.n149 VSSIO.n148 1.06277
R1061 VSSIO.n31 VSSIO.t225 0.8195
R1062 VSSIO.n31 VSSIO.t223 0.8195
R1063 VSSIO.n30 VSSIO.t219 0.8195
R1064 VSSIO.n30 VSSIO.t221 0.8195
R1065 VSSIO.n29 VSSIO.t215 0.8195
R1066 VSSIO.n29 VSSIO.t217 0.8195
R1067 VSSIO.n28 VSSIO.t211 0.8195
R1068 VSSIO.n28 VSSIO.t213 0.8195
R1069 VSSIO.n27 VSSIO.t185 0.8195
R1070 VSSIO.n27 VSSIO.t209 0.8195
R1071 VSSIO.n26 VSSIO.t199 0.8195
R1072 VSSIO.n26 VSSIO.t207 0.8195
R1073 VSSIO.n25 VSSIO.t203 0.8195
R1074 VSSIO.n25 VSSIO.t195 0.8195
R1075 VSSIO.n24 VSSIO.t197 0.8195
R1076 VSSIO.n24 VSSIO.t205 0.8195
R1077 VSSIO.n23 VSSIO.t193 0.8195
R1078 VSSIO.n23 VSSIO.t201 0.8195
R1079 VSSIO.n22 VSSIO.t189 0.8195
R1080 VSSIO.n22 VSSIO.t191 0.8195
R1081 VSSIO.n21 VSSIO.t187 0.8195
R1082 VSSIO.n21 VSSIO.t181 0.8195
R1083 VSSIO.n20 VSSIO.t183 0.8195
R1084 VSSIO.n20 VSSIO.t179 0.8195
R1085 VSSIO.n19 VSSIO.t175 0.8195
R1086 VSSIO.n19 VSSIO.t177 0.8195
R1087 VSSIO.n18 VSSIO.t171 0.8195
R1088 VSSIO.n18 VSSIO.t173 0.8195
R1089 VSSIO.n17 VSSIO.t167 0.8195
R1090 VSSIO.n17 VSSIO.t169 0.8195
R1091 VSSIO.n16 VSSIO.t155 0.8195
R1092 VSSIO.n16 VSSIO.t165 0.8195
R1093 VSSIO.n15 VSSIO.t163 0.8195
R1094 VSSIO.n15 VSSIO.t159 0.8195
R1095 VSSIO.n14 VSSIO.t157 0.8195
R1096 VSSIO.n14 VSSIO.t161 0.8195
R1097 VSSIO.n13 VSSIO.t151 0.8195
R1098 VSSIO.n13 VSSIO.t153 0.8195
R1099 VSSIO.n150 VSSIO.n149 0.7625
R1100 VSSIO.n155 VSSIO.n154 0.6005
R1101 VSSIO.n156 VSSIO.n155 0.6005
R1102 VSSIO.n157 VSSIO.n156 0.6005
R1103 VSSIO.n167 VSSIO.n42 0.6005
R1104 VSSIO.n154 VSSIO.n153 0.5855
R1105 VSSIO.n158 VSSIO.n42 0.5855
R1106 VSSIO.t49 VSSIO.n164 0.571276
R1107 VSSIO.n151 VSSIO.n150 0.4655
R1108 VSSIO.n153 VSSIO.n152 0.4655
R1109 VSSIO.n158 VSSIO.n157 0.4655
R1110 VSSIO.n167 VSSIO.n166 0.462773
R1111 VSSIO.n162 VSSIO.n42 0.462773
R1112 VSSIO.n159 VSSIO.n158 0.462773
R1113 VSSIO.n157 VSSIO.n46 0.462773
R1114 VSSIO.n156 VSSIO.n134 0.462773
R1115 VSSIO.n155 VSSIO.n136 0.462773
R1116 VSSIO.n154 VSSIO.n138 0.462773
R1117 VSSIO.n153 VSSIO.n140 0.462773
R1118 VSSIO.n152 VSSIO.n142 0.462773
R1119 VSSIO.n151 VSSIO.n144 0.462773
R1120 VSSIO.n149 VSSIO.n147 0.462773
R1121 VSSIO.n152 VSSIO.n151 0.4235
R1122 VSSIO.n70 VSSIO.t119 0.41
R1123 VSSIO.n70 VSSIO.t122 0.41
R1124 VSSIO.n69 VSSIO.t113 0.41
R1125 VSSIO.n69 VSSIO.t116 0.41
R1126 VSSIO.n68 VSSIO.t107 0.41
R1127 VSSIO.n68 VSSIO.t110 0.41
R1128 VSSIO.n67 VSSIO.t101 0.41
R1129 VSSIO.n67 VSSIO.t104 0.41
R1130 VSSIO.n66 VSSIO.t95 0.41
R1131 VSSIO.n66 VSSIO.t98 0.41
R1132 VSSIO.n65 VSSIO.t89 0.41
R1133 VSSIO.n65 VSSIO.t92 0.41
R1134 VSSIO.n64 VSSIO.t83 0.41
R1135 VSSIO.n64 VSSIO.t86 0.41
R1136 VSSIO.n63 VSSIO.t77 0.41
R1137 VSSIO.n63 VSSIO.t80 0.41
R1138 VSSIO.n62 VSSIO.t71 0.41
R1139 VSSIO.n62 VSSIO.t74 0.41
R1140 VSSIO.n61 VSSIO.t65 0.41
R1141 VSSIO.n61 VSSIO.t68 0.41
R1142 VSSIO.n60 VSSIO.t59 0.41
R1143 VSSIO.n60 VSSIO.t62 0.41
R1144 VSSIO.n59 VSSIO.t53 0.41
R1145 VSSIO.n59 VSSIO.t56 0.41
R1146 VSSIO.n58 VSSIO.t47 0.41
R1147 VSSIO.n58 VSSIO.t50 0.41
R1148 VSSIO.n57 VSSIO.t41 0.41
R1149 VSSIO.n57 VSSIO.t44 0.41
R1150 VSSIO.n56 VSSIO.t35 0.41
R1151 VSSIO.n56 VSSIO.t38 0.41
R1152 VSSIO.n55 VSSIO.t29 0.41
R1153 VSSIO.n55 VSSIO.t32 0.41
R1154 VSSIO.n54 VSSIO.t23 0.41
R1155 VSSIO.n54 VSSIO.t26 0.41
R1156 VSSIO.n53 VSSIO.t17 0.41
R1157 VSSIO.n53 VSSIO.t20 0.41
R1158 VSSIO.n52 VSSIO.t11 0.41
R1159 VSSIO.n52 VSSIO.t14 0.41
R1160 VSSIO.n177 VSSIO.n176 0.3605
R1161 VSSIO.n176 VSSIO.n175 0.3605
R1162 VSSIO.n175 VSSIO.n174 0.3605
R1163 VSSIO.n174 VSSIO.n173 0.3605
R1164 VSSIO.n173 VSSIO.n172 0.3605
R1165 VSSIO.n172 VSSIO.n171 0.3605
R1166 VSSIO.n171 VSSIO.n170 0.3605
R1167 VSSIO.n170 VSSIO.n169 0.3605
R1168 VSSIO.n41 VSSIO.n40 0.3605
R1169 VSSIO.n40 VSSIO.n39 0.3605
R1170 VSSIO.n39 VSSIO.n38 0.3605
R1171 VSSIO.n38 VSSIO.n37 0.3605
R1172 VSSIO.n37 VSSIO.n36 0.3605
R1173 VSSIO.n36 VSSIO.n35 0.3605
R1174 VSSIO.n35 VSSIO.n34 0.3605
R1175 VSSIO.n34 VSSIO.n33 0.3605
R1176 VSSIO.n33 VSSIO.n32 0.3605
R1177 VSSIO.n130 VSSIO.n90 0.3605
R1178 VSSIO.n90 VSSIO.n89 0.3605
R1179 VSSIO.n89 VSSIO.n88 0.3605
R1180 VSSIO.n88 VSSIO.n87 0.3605
R1181 VSSIO.n87 VSSIO.n86 0.3605
R1182 VSSIO.n86 VSSIO.n85 0.3605
R1183 VSSIO.n85 VSSIO.n84 0.3605
R1184 VSSIO.n84 VSSIO.n83 0.3605
R1185 VSSIO.n83 VSSIO.n82 0.3605
R1186 VSSIO.n82 VSSIO.n81 0.3605
R1187 VSSIO.n81 VSSIO.n80 0.3605
R1188 VSSIO.n80 VSSIO.n79 0.3605
R1189 VSSIO.n79 VSSIO.n78 0.3605
R1190 VSSIO.n78 VSSIO.n77 0.3605
R1191 VSSIO.n77 VSSIO.n76 0.3605
R1192 VSSIO.n76 VSSIO.n75 0.3605
R1193 VSSIO.n75 VSSIO.n74 0.3605
R1194 VSSIO.n74 VSSIO.n73 0.3605
R1195 VSSIO VSSIO.n177 0.35825
R1196 VSSIO.n32 VSSIO.n3 0.32225
R1197 VSSIO.n169 VSSIO.n168 0.32
R1198 VSSIO.n73 VSSIO.n72 0.25925
R1199 VSSIO VSSIO.n196 0.221777
R1200 VSSIO VSSIO.n198 0.1085
R1201 VSSIO.n72 VSSIO.n71 0.10175
R1202 VSSIO.n168 VSSIO.n41 0.041
R1203 VSSIO.n2 VSSIO 0.0272021
R1204 VSSIO VSSIO.t232 0.0122914
R1205 a_n7856_9000.n20 a_n7856_9000.t80 15.6427
R1206 a_n7856_9000.n39 a_n7856_9000.n0 6.66725
R1207 a_n7856_9000.n38 a_n7856_9000.n1 6.66725
R1208 a_n7856_9000.n37 a_n7856_9000.n2 6.66725
R1209 a_n7856_9000.n36 a_n7856_9000.n3 6.66725
R1210 a_n7856_9000.n35 a_n7856_9000.n4 6.66725
R1211 a_n7856_9000.n34 a_n7856_9000.n5 6.66725
R1212 a_n7856_9000.n33 a_n7856_9000.n6 6.66725
R1213 a_n7856_9000.n32 a_n7856_9000.n7 6.66725
R1214 a_n7856_9000.n31 a_n7856_9000.n8 6.66725
R1215 a_n7856_9000.n30 a_n7856_9000.n9 6.66725
R1216 a_n7856_9000.n29 a_n7856_9000.n10 6.66725
R1217 a_n7856_9000.n28 a_n7856_9000.n11 6.66725
R1218 a_n7856_9000.n27 a_n7856_9000.n12 6.66725
R1219 a_n7856_9000.n26 a_n7856_9000.n13 6.66725
R1220 a_n7856_9000.n25 a_n7856_9000.n14 6.66725
R1221 a_n7856_9000.n24 a_n7856_9000.n15 6.66725
R1222 a_n7856_9000.n23 a_n7856_9000.n16 6.66725
R1223 a_n7856_9000.n22 a_n7856_9000.n17 6.66725
R1224 a_n7856_9000.n21 a_n7856_9000.n18 6.66725
R1225 a_n7856_9000.n20 a_n7856_9000.n19 6.66725
R1226 a_n7856_9000.n59 a_n7856_9000.n58 6.34065
R1227 a_n7856_9000.n78 a_n7856_9000.n77 6.00576
R1228 a_n7856_9000.n59 a_n7856_9000.n57 6.00576
R1229 a_n7856_9000.n60 a_n7856_9000.n56 6.00576
R1230 a_n7856_9000.n61 a_n7856_9000.n55 6.00576
R1231 a_n7856_9000.n62 a_n7856_9000.n54 6.00576
R1232 a_n7856_9000.n63 a_n7856_9000.n53 6.00576
R1233 a_n7856_9000.n64 a_n7856_9000.n52 6.00576
R1234 a_n7856_9000.n65 a_n7856_9000.n51 6.00576
R1235 a_n7856_9000.n66 a_n7856_9000.n50 6.00576
R1236 a_n7856_9000.n67 a_n7856_9000.n49 6.00576
R1237 a_n7856_9000.n68 a_n7856_9000.n48 6.00576
R1238 a_n7856_9000.n69 a_n7856_9000.n47 6.00576
R1239 a_n7856_9000.n70 a_n7856_9000.n46 6.00576
R1240 a_n7856_9000.n71 a_n7856_9000.n45 6.00576
R1241 a_n7856_9000.n72 a_n7856_9000.n44 6.00576
R1242 a_n7856_9000.n73 a_n7856_9000.n43 6.00576
R1243 a_n7856_9000.n74 a_n7856_9000.n42 6.00576
R1244 a_n7856_9000.n75 a_n7856_9000.n41 6.00576
R1245 a_n7856_9000.n76 a_n7856_9000.n40 6.00576
R1246 a_n7856_9000.n77 a_n7856_9000.n39 2.08681
R1247 a_n7856_9000.n0 a_n7856_9000.t0 0.8195
R1248 a_n7856_9000.n0 a_n7856_9000.t1 0.8195
R1249 a_n7856_9000.n1 a_n7856_9000.t2 0.8195
R1250 a_n7856_9000.n1 a_n7856_9000.t3 0.8195
R1251 a_n7856_9000.n2 a_n7856_9000.t4 0.8195
R1252 a_n7856_9000.n2 a_n7856_9000.t5 0.8195
R1253 a_n7856_9000.n3 a_n7856_9000.t6 0.8195
R1254 a_n7856_9000.n3 a_n7856_9000.t7 0.8195
R1255 a_n7856_9000.n4 a_n7856_9000.t8 0.8195
R1256 a_n7856_9000.n4 a_n7856_9000.t9 0.8195
R1257 a_n7856_9000.n5 a_n7856_9000.t10 0.8195
R1258 a_n7856_9000.n5 a_n7856_9000.t11 0.8195
R1259 a_n7856_9000.n6 a_n7856_9000.t12 0.8195
R1260 a_n7856_9000.n6 a_n7856_9000.t13 0.8195
R1261 a_n7856_9000.n7 a_n7856_9000.t14 0.8195
R1262 a_n7856_9000.n7 a_n7856_9000.t15 0.8195
R1263 a_n7856_9000.n8 a_n7856_9000.t16 0.8195
R1264 a_n7856_9000.n8 a_n7856_9000.t17 0.8195
R1265 a_n7856_9000.n9 a_n7856_9000.t18 0.8195
R1266 a_n7856_9000.n9 a_n7856_9000.t19 0.8195
R1267 a_n7856_9000.n10 a_n7856_9000.t20 0.8195
R1268 a_n7856_9000.n10 a_n7856_9000.t21 0.8195
R1269 a_n7856_9000.n11 a_n7856_9000.t22 0.8195
R1270 a_n7856_9000.n11 a_n7856_9000.t23 0.8195
R1271 a_n7856_9000.n12 a_n7856_9000.t24 0.8195
R1272 a_n7856_9000.n12 a_n7856_9000.t25 0.8195
R1273 a_n7856_9000.n13 a_n7856_9000.t26 0.8195
R1274 a_n7856_9000.n13 a_n7856_9000.t27 0.8195
R1275 a_n7856_9000.n14 a_n7856_9000.t28 0.8195
R1276 a_n7856_9000.n14 a_n7856_9000.t29 0.8195
R1277 a_n7856_9000.n15 a_n7856_9000.t30 0.8195
R1278 a_n7856_9000.n15 a_n7856_9000.t31 0.8195
R1279 a_n7856_9000.n16 a_n7856_9000.t32 0.8195
R1280 a_n7856_9000.n16 a_n7856_9000.t33 0.8195
R1281 a_n7856_9000.n17 a_n7856_9000.t34 0.8195
R1282 a_n7856_9000.n17 a_n7856_9000.t35 0.8195
R1283 a_n7856_9000.n18 a_n7856_9000.t36 0.8195
R1284 a_n7856_9000.n18 a_n7856_9000.t37 0.8195
R1285 a_n7856_9000.n19 a_n7856_9000.t38 0.8195
R1286 a_n7856_9000.n19 a_n7856_9000.t39 0.8195
R1287 a_n7856_9000.n78 a_n7856_9000.t78 0.3645
R1288 a_n7856_9000.t79 a_n7856_9000.n78 0.3645
R1289 a_n7856_9000.n58 a_n7856_9000.t40 0.3645
R1290 a_n7856_9000.n58 a_n7856_9000.t41 0.3645
R1291 a_n7856_9000.n57 a_n7856_9000.t42 0.3645
R1292 a_n7856_9000.n57 a_n7856_9000.t43 0.3645
R1293 a_n7856_9000.n56 a_n7856_9000.t44 0.3645
R1294 a_n7856_9000.n56 a_n7856_9000.t45 0.3645
R1295 a_n7856_9000.n55 a_n7856_9000.t46 0.3645
R1296 a_n7856_9000.n55 a_n7856_9000.t47 0.3645
R1297 a_n7856_9000.n54 a_n7856_9000.t48 0.3645
R1298 a_n7856_9000.n54 a_n7856_9000.t49 0.3645
R1299 a_n7856_9000.n53 a_n7856_9000.t50 0.3645
R1300 a_n7856_9000.n53 a_n7856_9000.t51 0.3645
R1301 a_n7856_9000.n52 a_n7856_9000.t52 0.3645
R1302 a_n7856_9000.n52 a_n7856_9000.t53 0.3645
R1303 a_n7856_9000.n51 a_n7856_9000.t54 0.3645
R1304 a_n7856_9000.n51 a_n7856_9000.t55 0.3645
R1305 a_n7856_9000.n50 a_n7856_9000.t56 0.3645
R1306 a_n7856_9000.n50 a_n7856_9000.t57 0.3645
R1307 a_n7856_9000.n49 a_n7856_9000.t58 0.3645
R1308 a_n7856_9000.n49 a_n7856_9000.t59 0.3645
R1309 a_n7856_9000.n48 a_n7856_9000.t60 0.3645
R1310 a_n7856_9000.n48 a_n7856_9000.t61 0.3645
R1311 a_n7856_9000.n47 a_n7856_9000.t62 0.3645
R1312 a_n7856_9000.n47 a_n7856_9000.t63 0.3645
R1313 a_n7856_9000.n46 a_n7856_9000.t64 0.3645
R1314 a_n7856_9000.n46 a_n7856_9000.t65 0.3645
R1315 a_n7856_9000.n45 a_n7856_9000.t66 0.3645
R1316 a_n7856_9000.n45 a_n7856_9000.t67 0.3645
R1317 a_n7856_9000.n44 a_n7856_9000.t68 0.3645
R1318 a_n7856_9000.n44 a_n7856_9000.t69 0.3645
R1319 a_n7856_9000.n43 a_n7856_9000.t70 0.3645
R1320 a_n7856_9000.n43 a_n7856_9000.t71 0.3645
R1321 a_n7856_9000.n42 a_n7856_9000.t72 0.3645
R1322 a_n7856_9000.n42 a_n7856_9000.t73 0.3645
R1323 a_n7856_9000.n41 a_n7856_9000.t74 0.3645
R1324 a_n7856_9000.n41 a_n7856_9000.t75 0.3645
R1325 a_n7856_9000.n40 a_n7856_9000.t76 0.3645
R1326 a_n7856_9000.n40 a_n7856_9000.t77 0.3645
R1327 a_n7856_9000.n60 a_n7856_9000.n59 0.335384
R1328 a_n7856_9000.n61 a_n7856_9000.n60 0.335384
R1329 a_n7856_9000.n62 a_n7856_9000.n61 0.335384
R1330 a_n7856_9000.n63 a_n7856_9000.n62 0.335384
R1331 a_n7856_9000.n64 a_n7856_9000.n63 0.335384
R1332 a_n7856_9000.n65 a_n7856_9000.n64 0.335384
R1333 a_n7856_9000.n66 a_n7856_9000.n65 0.335384
R1334 a_n7856_9000.n67 a_n7856_9000.n66 0.335384
R1335 a_n7856_9000.n68 a_n7856_9000.n67 0.335384
R1336 a_n7856_9000.n69 a_n7856_9000.n68 0.335384
R1337 a_n7856_9000.n70 a_n7856_9000.n69 0.335384
R1338 a_n7856_9000.n71 a_n7856_9000.n70 0.335384
R1339 a_n7856_9000.n72 a_n7856_9000.n71 0.335384
R1340 a_n7856_9000.n73 a_n7856_9000.n72 0.335384
R1341 a_n7856_9000.n74 a_n7856_9000.n73 0.335384
R1342 a_n7856_9000.n75 a_n7856_9000.n74 0.335384
R1343 a_n7856_9000.n76 a_n7856_9000.n75 0.335384
R1344 a_n7856_9000.n77 a_n7856_9000.n76 0.335384
R1345 a_n7856_9000.n39 a_n7856_9000.n38 0.253132
R1346 a_n7856_9000.n38 a_n7856_9000.n37 0.253132
R1347 a_n7856_9000.n37 a_n7856_9000.n36 0.253132
R1348 a_n7856_9000.n36 a_n7856_9000.n35 0.253132
R1349 a_n7856_9000.n35 a_n7856_9000.n34 0.253132
R1350 a_n7856_9000.n34 a_n7856_9000.n33 0.253132
R1351 a_n7856_9000.n33 a_n7856_9000.n32 0.253132
R1352 a_n7856_9000.n32 a_n7856_9000.n31 0.253132
R1353 a_n7856_9000.n31 a_n7856_9000.n30 0.253132
R1354 a_n7856_9000.n30 a_n7856_9000.n29 0.253132
R1355 a_n7856_9000.n29 a_n7856_9000.n28 0.253132
R1356 a_n7856_9000.n28 a_n7856_9000.n27 0.253132
R1357 a_n7856_9000.n27 a_n7856_9000.n26 0.253132
R1358 a_n7856_9000.n26 a_n7856_9000.n25 0.253132
R1359 a_n7856_9000.n25 a_n7856_9000.n24 0.253132
R1360 a_n7856_9000.n24 a_n7856_9000.n23 0.253132
R1361 a_n7856_9000.n23 a_n7856_9000.n22 0.253132
R1362 a_n7856_9000.n22 a_n7856_9000.n21 0.253132
R1363 a_n7856_9000.n21 a_n7856_9000.n20 0.253132
R1364 a_628_11080.t0 a_628_11080.t1 6.08195
R1365 a_n3172_11080.t0 a_n3172_11080.t1 6.08195
R1366 a_n4804_11920.t0 a_n4804_11920.t1 10.5985
R1367 a_2028_11080.t3 a_2028_11080.t2 96.4648
R1368 a_2028_11080.n0 a_2028_11080.t3 56.8672
R1369 a_2028_11080.n0 a_2028_11080.t0 5.15205
R1370 a_2028_11080.t1 a_2028_11080.n0 2.69247
R1371 a_628_11920.t4 a_628_11920.t3 96.4648
R1372 a_628_11920.n0 a_628_11920.t4 51.971
R1373 a_628_11920.n0 a_628_11920.t0 9.50876
R1374 a_628_11920.n1 a_628_11920.n0 5.063
R1375 a_628_11920.n1 a_628_11920.t2 4.87376
R1376 a_628_11920.t1 a_628_11920.n1 2.97195
R1377 a_n972_11080.t3 a_n972_11080.t2 96.4648
R1378 a_n972_11080.n0 a_n972_11080.t3 55.4272
R1379 a_n972_11080.n0 a_n972_11080.t1 5.15205
R1380 a_n972_11080.t0 a_n972_11080.n0 2.69247
R1381 a_n1772_11080.t3 a_n1772_11080.t2 96.4648
R1382 a_n1772_11080.n0 a_n1772_11080.t3 54.9472
R1383 a_n1772_11080.n0 a_n1772_11080.t0 5.15205
R1384 a_n1772_11080.t1 a_n1772_11080.n0 2.69247
R1385 a_n3172_11920.t4 a_n3172_11920.t3 96.4648
R1386 a_n3172_11920.n0 a_n3172_11920.t4 50.051
R1387 a_n3172_11920.n0 a_n3172_11920.t0 9.50876
R1388 a_n3172_11920.n1 a_n3172_11920.n0 5.063
R1389 a_n3172_11920.n1 a_n3172_11920.t2 4.87376
R1390 a_n3172_11920.t1 a_n3172_11920.n1 2.97195
R1391 a_n6172_11080.t3 a_n6172_11080.t2 96.4648
R1392 a_n6172_11080.n0 a_n6172_11080.t3 55.5652
R1393 a_n6172_11080.n0 a_n6172_11080.t0 5.15205
R1394 a_n6172_11080.t1 a_n6172_11080.n0 2.69247
R1395 a_n4948_11920.t6 a_n4948_11920.t4 96.4648
R1396 a_n4948_11920.t5 a_n4948_11920.t3 96.4648
R1397 a_n4948_11920.n0 a_n4948_11920.t5 45.179
R1398 a_n4948_11920.n0 a_n4948_11920.t6 41.759
R1399 a_n4948_11920.n1 a_n4948_11920.t1 10.1312
R1400 a_n4948_11920.n2 a_n4948_11920.n0 7.8772
R1401 a_n4948_11920.n1 a_n4948_11920.t2 7.09797
R1402 a_n4948_11920.t0 a_n4948_11920.n2 7.09797
R1403 a_n4948_11920.n2 a_n4948_11920.n1 0.607022
R1404 a_n5372_11080.t3 a_n5372_11080.t2 119.407
R1405 a_n5372_11080.n0 a_n5372_11080.t3 53.8564
R1406 a_n5372_11080.n0 a_n5372_11080.t0 5.15205
R1407 a_n5372_11080.t1 a_n5372_11080.n0 2.69247
C0 GP VDDIO 7.34963f
C1 GN VSSIO 12.17808f
C2 GP VSSIO 8.30949f
C3 PU_OK VSSIO 4.38433f
C4 OE_N VSSIO 4.52714f
C5 OUT VSSIO 5.80163f
C6 PAD VSSIO 0.19764p
C7 VDDIO VSSIO 85.98227f
C8 VDDIO.t102 VSSIO 2.91501f
C9 OUT.n0 VSSIO 2.73011f
C10 GP.n39 VSSIO 2.06022f
.ends
