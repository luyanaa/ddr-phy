* SPICE3 file created from gf180_pad_core_flat.ext - technology: gf180mcuD

.option scale=5n

.subckt gf180_pad_core_flat GP GN PAD VSSIO VDDIO IN OUT OE_N PU_OK
X0 a_n7856_9000.t16 GP.t25 VDDIO.t41 VDDIO.t40 pfet_03v3 ad=52n pd=1.104m as=52n ps=1.104m w=1000 l=56
X1 VSSIO.t193 VSSIO.t191 PAD.t36 VSSIO.t192 nfet_03v3 ad=20.8n pd=0.504m as=20.8n ps=0.504m w=400 l=56
X2 VSSIO.t127 VSSIO.t125 PAD.t18 VSSIO.t126 nfet_03v3 ad=20.8n pd=0.504m as=20.8n ps=0.504m w=400 l=56
X3 PAD.t3 VSSIO.t101 VSSIO.t103 VSSIO.t102 nfet_03v3 ad=20.8n pd=0.504m as=20.8n ps=0.504m w=400 l=56
X4 VSSIO.t74 GN.t2 a_n7856_9000.t79 VSSIO.t73 nfet_03v3 ad=35.2n pd=0.976m as=20.8n ps=0.504m w=400 l=56
X5 PAD.t23 VSSIO.t152 VSSIO.t154 VSSIO.t153 nfet_03v3 ad=20.8n pd=0.504m as=20.8n ps=0.504m w=400 l=56
X6 PAD.t15 VSSIO.t137 VSSIO.t139 VSSIO.t138 nfet_03v3 ad=20.8n pd=0.504m as=20.8n ps=0.504m w=400 l=56
X7 a_n7856_9000.t56 GN.t25 VSSIO.t33 VSSIO.t32 nfet_03v3 ad=20.8n pd=0.504m as=20.8n ps=0.504m w=400 l=56
X8 VDDIO.t79 GP.t2 a_n7856_9000.t39 VDDIO.t78 pfet_03v3 ad=88n pd=2.176m as=52n ps=1.104m w=1000 l=56
X9 VDDIO.t23 GP.t32 a_n7856_9000.t9 VDDIO.t22 pfet_03v3 ad=52n pd=1.104m as=52n ps=1.104m w=1000 l=56
X10 a_n4804_11920.t1 PU_OK.t1 a_n4948_11920.t0 VSSIO.t52 nfet_03v3 ad=17.6n pd=0.576m as=17.6n ps=0.576m w=200 l=56
X11 a_n3172_11920.t0 a_n6172_11080.t2 a_n3172_11080.t1 VDDIO.t93 pfet_03v3 ad=35.2n pd=0.976m as=35.2n ps=0.976m w=400 l=56
X12 a_n7856_9000.t10 GP.t31 VDDIO.t25 VDDIO.t24 pfet_03v3 ad=52n pd=1.104m as=52n ps=1.104m w=1000 l=56
X13 VSSIO.t5 GN.t18 a_n7856_9000.t63 VSSIO.t4 nfet_03v3 ad=20.8n pd=0.504m as=20.8n ps=0.504m w=400 l=56
X14 a_n7856_9000.t32 GP.t9 VDDIO.t67 VDDIO.t66 pfet_03v3 ad=52n pd=1.104m as=52n ps=1.104m w=1000 l=56
X15 VSSIO.t70 a_n5372_11080.t3 a_n4804_11920.t0 VSSIO.t69 nfet_03v3 ad=17.6n pd=0.576m as=17.6n ps=0.576m w=200 l=56
X16 VSSIO.t13 GN.t16 a_n7856_9000.t65 VSSIO.t12 nfet_03v3 ad=20.8n pd=0.504m as=20.8n ps=0.504m w=400 l=56
X17 a_n3172_11920.t1 a_n6172_11080.t3 VSSIO.t219 VSSIO.t218 nfet_03v3 ad=17.6n pd=0.576m as=17.6n ps=0.576m w=200 l=56
X18 VSSIO.t136 VSSIO.t134 PAD.t14 VSSIO.t135 nfet_03v3 ad=20.8n pd=0.504m as=20.8n ps=0.504m w=400 l=56
X19 a_n7856_9000.t2 GP.t39 VDDIO.t9 VDDIO.t8 pfet_03v3 ad=52n pd=1.104m as=52n ps=1.104m w=1000 l=56
X20 VSSIO.t181 VSSIO.t179 PAD.t34 VSSIO.t180 nfet_03v3 ad=20.8n pd=0.504m as=20.8n ps=0.504m w=400 l=56
X21 PAD.t1 VSSIO.t86 VSSIO.t88 VSSIO.t87 nfet_03v3 ad=20.8n pd=0.504m as=35.2n ps=0.976m w=400 l=56
X22 a_n7856_9000.t62 GN.t19 VSSIO.t21 VSSIO.t20 nfet_03v3 ad=20.8n pd=0.504m as=20.8n ps=0.504m w=400 l=56
X23 VDDIO.t73 GP.t8 a_n7856_9000.t33 VDDIO.t72 pfet_03v3 ad=52n pd=1.104m as=52n ps=1.104m w=1000 l=56
X24 a_n972_11080.t1 a_n1772_11080.t2 VDDIO.t107 VDDIO.t106 pfet_03v3 ad=35.2n pd=0.976m as=35.2n ps=0.976m w=400 l=56
X25 PAD.t31 VSSIO.t176 VSSIO.t178 VSSIO.t177 nfet_03v3 ad=20.8n pd=0.504m as=20.8n ps=0.504m w=400 l=56
X26 a_n7856_9000.t70 GN.t11 VSSIO.t64 VSSIO.t63 nfet_03v3 ad=20.8n pd=0.504m as=20.8n ps=0.504m w=400 l=56
X27 VDDIO.t5 GP.t38 a_n7856_9000.t3 VDDIO.t4 pfet_03v3 ad=52n pd=1.104m as=52n ps=1.104m w=1000 l=56
X28 VSSIO.t205 VSSIO.t203 PAD.t40 VSSIO.t204 nfet_03v3 ad=35.2n pd=0.976m as=20.8n ps=0.504m w=400 l=56
X29 a_n972_11080.t0 a_n1772_11080.t3 VSSIO.t81 VSSIO.t80 nfet_03v3 ad=17.6n pd=0.576m as=17.6n ps=0.576m w=200 l=56
X30 VSSIO.t225 GN.t12 a_n7856_9000.t69 VSSIO.t224 nfet_03v3 ad=20.8n pd=0.504m as=20.8n ps=0.504m w=400 l=56
X31 a_n7856_9000.t26 GP.t15 VDDIO.t57 VDDIO.t56 pfet_03v3 ad=52n pd=1.104m as=52n ps=1.104m w=1000 l=56
X32 PAD.t37 VSSIO.t197 VSSIO.t199 VSSIO.t198 nfet_03v3 ad=20.8n pd=0.504m as=20.8n ps=0.504m w=400 l=56
X33 a_n7856_9000.t24 GP.t17 VDDIO.t53 VDDIO.t52 pfet_03v3 ad=52n pd=1.104m as=52n ps=1.104m w=1000 l=56
X34 VSSIO.t211 GN.t10 a_n7856_9000.t71 VSSIO.t210 nfet_03v3 ad=20.8n pd=0.504m as=20.8n ps=0.504m w=400 l=56
D0 VSSIO.t232 VDDIO.t98 diode_pd2nw_03v3 pj=8000 area=4e+06
X35 VSSIO.t1 GN.t38 a_n7856_9000.t43 VSSIO.t0 nfet_03v3 ad=20.8n pd=0.504m as=20.8n ps=0.504m w=400 l=56
D1 VSSIO.t206 PAD.t44 diode_nd2ps_03v3 pj=6400 area=2.56e+06
X36 VSSIO.t142 VSSIO.t140 PAD.t16 VSSIO.t141 nfet_03v3 ad=20.8n pd=0.504m as=20.8n ps=0.504m w=400 l=56
X37 a_n7856_9000.t48 GN.t33 VSSIO.t3 VSSIO.t2 nfet_03v3 ad=20.8n pd=0.504m as=20.8n ps=0.504m w=400 l=56
X38 a_n7856_9000.t42 GN.t39 VSSIO.t17 VSSIO.t16 nfet_03v3 ad=20.8n pd=0.504m as=20.8n ps=0.504m w=400 l=56
X39 VDDIO.t49 GP.t22 a_n7856_9000.t19 VDDIO.t48 pfet_03v3 ad=52n pd=1.104m as=52n ps=1.104m w=1000 l=56
X40 a_n7856_9000.t76 GN.t5 VSSIO.t217 VSSIO.t216 nfet_03v3 ad=20.8n pd=0.504m as=20.8n ps=0.504m w=400 l=56
X41 VDDIO.t39 GP.t24 a_n7856_9000.t17 VDDIO.t38 pfet_03v3 ad=52n pd=1.104m as=52n ps=1.104m w=1000 l=56
X42 PAD.t29 VSSIO.t167 VSSIO.t169 VSSIO.t168 nfet_03v3 ad=20.8n pd=0.504m as=20.8n ps=0.504m w=400 l=56
X43 a_n7856_9000.t78 GN.t3 VSSIO.t83 VSSIO.t82 nfet_03v3 ad=20.8n pd=0.504m as=20.8n ps=0.504m w=400 l=56
X44 VSSIO.t19 GN.t34 a_n7856_9000.t47 VSSIO.t18 nfet_03v3 ad=20.8n pd=0.504m as=20.8n ps=0.504m w=400 l=56
X45 a_n7856_9000.t20 GP.t21 VDDIO.t47 VDDIO.t46 pfet_03v3 ad=52n pd=1.104m as=52n ps=1.104m w=1000 l=56
X46 VSSIO.t163 VSSIO.t161 PAD.t26 VSSIO.t162 nfet_03v3 ad=20.8n pd=0.504m as=20.8n ps=0.504m w=400 l=56
X47 VSSIO.t39 GN.t4 a_n7856_9000.t77 VSSIO.t38 nfet_03v3 ad=20.8n pd=0.504m as=20.8n ps=0.504m w=400 l=56
X48 VSSIO.t56 GN.t26 a_n7856_9000.t55 VSSIO.t55 nfet_03v3 ad=20.8n pd=0.504m as=20.8n ps=0.504m w=400 l=56
X49 a_n7856_9000.t18 GP.t23 VDDIO.t43 VDDIO.t42 pfet_03v3 ad=52n pd=1.104m as=52n ps=1.104m w=1000 l=56
X50 IN.t0 PAD.t42 VSSIO.t79 VSSIO.t78 nfet_03v3 ad=35.2n pd=0.976m as=35.2n ps=0.976m w=400 l=56
X51 a_n7856_9000.t12 GP.t29 VDDIO.t21 VDDIO.t20 pfet_03v3 ad=52n pd=1.104m as=52n ps=1.104m w=1000 l=56
X52 PAD.t35 VSSIO.t188 VSSIO.t190 VSSIO.t189 nfet_03v3 ad=20.8n pd=0.504m as=20.8n ps=0.504m w=400 l=56
X53 VSSIO.t124 VSSIO.t122 PAD.t12 VSSIO.t123 nfet_03v3 ad=20.8n pd=0.504m as=20.8n ps=0.504m w=400 l=56
X54 a_n7856_9000.t54 GN.t27 VSSIO.t49 VSSIO.t48 nfet_03v3 ad=20.8n pd=0.504m as=20.8n ps=0.504m w=400 l=56
X55 VSSIO.t184 VSSIO.t182 PAD.t32 VSSIO.t183 nfet_03v3 ad=20.8n pd=0.504m as=20.8n ps=0.504m w=400 l=56
X56 VDDIO.t27 GP.t28 a_n7856_9000.t13 VDDIO.t26 pfet_03v3 ad=52n pd=1.104m as=52n ps=1.104m w=1000 l=56
X57 VDDIO.t19 GP.t30 a_n7856_9000.t11 VDDIO.t18 pfet_03v3 ad=52n pd=1.104m as=52n ps=1.104m w=1000 l=56
X58 PAD.t9 VSSIO.t113 VSSIO.t115 VSSIO.t114 nfet_03v3 ad=20.8n pd=0.504m as=20.8n ps=0.504m w=400 l=56
X59 VSSIO.t202 VSSIO.t200 PAD.t38 VSSIO.t201 nfet_03v3 ad=20.8n pd=0.504m as=20.8n ps=0.504m w=400 l=56
X60 VSSIO.t51 GN.t20 a_n7856_9000.t61 VSSIO.t50 nfet_03v3 ad=20.8n pd=0.504m as=20.8n ps=0.504m w=400 l=56
X61 a_n7856_9000.t34 GP.t7 VDDIO.t71 VDDIO.t70 pfet_03v3 ad=52n pd=1.104m as=52n ps=1.104m w=1000 l=56
X62 a_n1772_11080.t0 a_n3172_11920.t3 VDDIO.t92 VDDIO.t91 pfet_03v3 ad=35.2n pd=0.976m as=35.2n ps=0.976m w=400 l=56
X63 a_n7856_9000.t6 GP.t35 VDDIO.t13 VDDIO.t12 pfet_03v3 ad=52n pd=1.104m as=52n ps=1.104m w=1000 l=56
X64 a_n7856_9000.t4 GP.t37 VDDIO.t11 VDDIO.t10 pfet_03v3 ad=52n pd=1.104m as=52n ps=1.104m w=1000 l=56
X65 a_2028_11080.t0 a_628_11920.t3 VDDIO.t95 VDDIO.t94 pfet_03v3 ad=35.2n pd=0.976m as=35.2n ps=0.976m w=400 l=56
X66 VDDIO.t69 GP.t6 a_n7856_9000.t35 VDDIO.t68 pfet_03v3 ad=52n pd=1.104m as=52n ps=1.104m w=1000 l=56
X67 a_n1772_11080.t1 a_n3172_11920.t4 VSSIO.t231 VSSIO.t230 nfet_03v3 ad=17.6n pd=0.576m as=17.6n ps=0.576m w=200 l=56
X68 PAD.t21 VSSIO.t149 VSSIO.t151 VSSIO.t150 nfet_03v3 ad=20.8n pd=0.504m as=35.2n ps=0.976m w=400 l=56
X69 a_n7856_9000.t68 GN.t13 VSSIO.t43 VSSIO.t42 nfet_03v3 ad=20.8n pd=0.504m as=20.8n ps=0.504m w=400 l=56
X70 VDDIO.t7 GP.t36 a_n7856_9000.t5 VDDIO.t6 pfet_03v3 ad=52n pd=1.104m as=52n ps=1.104m w=1000 l=56
X71 VDDIO.t61 GP.t14 a_n7856_9000.t27 VDDIO.t60 pfet_03v3 ad=52n pd=1.104m as=52n ps=1.104m w=1000 l=56
X72 a_2028_11080.t1 a_628_11920.t4 VSSIO.t209 VSSIO.t208 nfet_03v3 ad=17.6n pd=0.576m as=17.6n ps=0.576m w=200 l=56
X73 a_n7856_9000.t40 GN.t41 VSSIO.t7 VSSIO.t6 nfet_03v3 ad=20.8n pd=0.504m as=35.2n ps=0.976m w=400 l=56
X74 PAD.t7 VSSIO.t107 VSSIO.t109 VSSIO.t108 nfet_03v3 ad=20.8n pd=0.504m as=20.8n ps=0.504m w=400 l=56
X75 PAD.t27 VSSIO.t164 VSSIO.t166 VSSIO.t165 nfet_03v3 ad=20.8n pd=0.504m as=20.8n ps=0.504m w=400 l=56
X76 VSSIO.t35 GN.t14 a_n7856_9000.t67 VSSIO.t34 nfet_03v3 ad=20.8n pd=0.504m as=20.8n ps=0.504m w=400 l=56
X77 a_n7856_9000.t28 GP.t13 VDDIO.t59 VDDIO.t58 pfet_03v3 ad=52n pd=1.104m as=52n ps=1.104m w=1000 l=56
X78 PAD.t19 VSSIO.t143 VSSIO.t145 VSSIO.t144 nfet_03v3 ad=20.8n pd=0.504m as=20.8n ps=0.504m w=400 l=56
X79 VSSIO.t106 VSSIO.t104 PAD.t4 VSSIO.t105 nfet_03v3 ad=20.8n pd=0.504m as=20.8n ps=0.504m w=400 l=56
X80 a_n4948_11920.t1 PU_OK.t0 VDDIO.t105 VDDIO.t104 pfet_03v3 ad=35.2n pd=0.976m as=35.2n ps=0.976m w=400 l=56
X81 a_n7856_9000.t0 GP.t41 VDDIO.t1 VDDIO.t0 pfet_03v3 ad=52n pd=1.104m as=88n ps=2.176m w=1000 l=56
X82 VSSIO.t23 GN.t40 a_n7856_9000.t41 VSSIO.t22 nfet_03v3 ad=20.8n pd=0.504m as=20.8n ps=0.504m w=400 l=56
X83 VSSIO.t157 VSSIO.t155 PAD.t24 VSSIO.t156 nfet_03v3 ad=20.8n pd=0.504m as=20.8n ps=0.504m w=400 l=56
X84 VSSIO.t227 GN.t6 a_n7856_9000.t75 VSSIO.t226 nfet_03v3 ad=20.8n pd=0.504m as=20.8n ps=0.504m w=400 l=56
X85 PAD.t13 VSSIO.t128 VSSIO.t130 VSSIO.t129 nfet_03v3 ad=20.8n pd=0.504m as=20.8n ps=0.504m w=400 l=56
X86 a_n7856_9000.t80 PAD.t0 VSSIO.t75 ppolyf_u r_width=4400 r_length=280
X87 a_n7856_9000.t46 GN.t35 VSSIO.t72 VSSIO.t71 nfet_03v3 ad=20.8n pd=0.504m as=20.8n ps=0.504m w=400 l=56
X88 a_n4948_11920.t2 a_n5372_11080.t2 VDDIO.t109 VDDIO.t108 pfet_03v3 ad=35.2n pd=0.976m as=35.2n ps=0.976m w=400 l=56
X89 PAD.t33 VSSIO.t185 VSSIO.t187 VSSIO.t186 nfet_03v3 ad=20.8n pd=0.504m as=20.8n ps=0.504m w=400 l=56
X90 VDDIO.t45 GP.t20 a_n7856_9000.t21 VDDIO.t44 pfet_03v3 ad=52n pd=1.104m as=52n ps=1.104m w=1000 l=56
X91 VSSIO.t121 VSSIO.t119 PAD.t10 VSSIO.t120 nfet_03v3 ad=20.8n pd=0.504m as=20.8n ps=0.504m w=400 l=56
X92 a_n7856_9000.t74 GN.t7 VSSIO.t37 VSSIO.t36 nfet_03v3 ad=20.8n pd=0.504m as=20.8n ps=0.504m w=400 l=56
X93 VSSIO.t175 VSSIO.t173 PAD.t30 VSSIO.t174 nfet_03v3 ad=20.8n pd=0.504m as=20.8n ps=0.504m w=400 l=56
X94 GN.t1 a_2028_11080.t2 VDDIO.t97 VDDIO.t96 pfet_03v3 ad=35.2n pd=0.976m as=35.2n ps=0.976m w=400 l=56
X95 VSSIO.t45 GN.t30 a_n7856_9000.t51 VSSIO.t44 nfet_03v3 ad=20.8n pd=0.504m as=20.8n ps=0.504m w=400 l=56
X96 VSSIO.t213 GN.t28 a_n7856_9000.t53 VSSIO.t212 nfet_03v3 ad=20.8n pd=0.504m as=20.8n ps=0.504m w=400 l=56
X97 GN.t0 a_2028_11080.t3 VSSIO.t66 VSSIO.t65 nfet_03v3 ad=17.6n pd=0.576m as=17.6n ps=0.576m w=200 l=56
X98 a_n7856_9000.t14 GP.t27 VDDIO.t29 VDDIO.t28 pfet_03v3 ad=52n pd=1.104m as=52n ps=1.104m w=1000 l=56
X99 VSSIO.t94 VSSIO.t92 PAD.t22 VSSIO.t93 nfet_03v3 ad=20.8n pd=0.504m as=20.8n ps=0.504m w=400 l=56
X100 a_n7856_9000.t52 GN.t29 VSSIO.t47 VSSIO.t46 nfet_03v3 ad=20.8n pd=0.504m as=20.8n ps=0.504m w=400 l=56
X101 a_n7856_9000.t58 GN.t23 VSSIO.t223 VSSIO.t222 nfet_03v3 ad=20.8n pd=0.504m as=20.8n ps=0.504m w=400 l=56
X102 a_n5372_11080.t1 OE_N.t0 VDDIO.t86 VDDIO.t85 pfet_03v3 ad=35.2n pd=0.976m as=35.2n ps=0.976m w=400 l=56
X103 a_628_11920.t0 OUT.t0 a_628_11080.t1 VDDIO.t84 pfet_03v3 ad=35.2n pd=0.976m as=35.2n ps=0.976m w=400 l=56
X104 VDDIO.t31 GP.t26 a_n7856_9000.t15 VDDIO.t30 pfet_03v3 ad=52n pd=1.104m as=52n ps=1.104m w=1000 l=56
X105 VDDIO.t75 GP.t4 a_n7856_9000.t37 VDDIO.t74 pfet_03v3 ad=52n pd=1.104m as=52n ps=1.104m w=1000 l=56
X106 a_n7856_9000.t60 GN.t21 VSSIO.t215 VSSIO.t214 nfet_03v3 ad=20.8n pd=0.504m as=20.8n ps=0.504m w=400 l=56
X107 VDDIO.t15 GP.t34 a_n7856_9000.t7 VDDIO.t14 pfet_03v3 ad=52n pd=1.104m as=52n ps=1.104m w=1000 l=56
X108 VSSIO.t172 VSSIO.t170 PAD.t28 VSSIO.t171 nfet_03v3 ad=20.8n pd=0.504m as=20.8n ps=0.504m w=400 l=56
D2 VSSIO.t76 PAD.t43 diode_nd2ps_03v3 pj=6400 area=2.56e+06
X109 VSSIO.t41 GN.t24 a_n7856_9000.t57 VSSIO.t40 nfet_03v3 ad=20.8n pd=0.504m as=20.8n ps=0.504m w=400 l=56
X110 a_n5372_11080.t0 OE_N.t1 VSSIO.t85 VSSIO.t84 nfet_03v3 ad=17.6n pd=0.576m as=17.6n ps=0.576m w=200 l=56
X111 a_628_11920.t1 OUT.t2 VSSIO.t68 VSSIO.t67 nfet_03v3 ad=17.6n pd=0.576m as=17.6n ps=0.576m w=200 l=56
X112 a_n7856_9000.t38 GP.t3 VDDIO.t77 VDDIO.t76 pfet_03v3 ad=52n pd=1.104m as=52n ps=1.104m w=1000 l=56
X113 VSSIO.t148 VSSIO.t146 PAD.t20 VSSIO.t147 nfet_03v3 ad=35.2n pd=0.976m as=20.8n ps=0.504m w=400 l=56
X114 PAD.t5 VSSIO.t98 VSSIO.t100 VSSIO.t99 nfet_03v3 ad=20.8n pd=0.504m as=20.8n ps=0.504m w=400 l=56
X115 VSSIO.t62 GN.t22 a_n7856_9000.t59 VSSIO.t61 nfet_03v3 ad=20.8n pd=0.504m as=20.8n ps=0.504m w=400 l=56
X116 a_n7856_9000.t36 GP.t5 VDDIO.t33 VDDIO.t32 pfet_03v3 ad=52n pd=1.104m as=52n ps=1.104m w=1000 l=56
X117 PAD.t25 VSSIO.t158 VSSIO.t160 VSSIO.t159 nfet_03v3 ad=20.8n pd=0.504m as=20.8n ps=0.504m w=400 l=56
X118 a_n7856_9000.t8 GP.t33 VDDIO.t17 VDDIO.t16 pfet_03v3 ad=52n pd=1.104m as=52n ps=1.104m w=1000 l=56
X119 PAD.t17 VSSIO.t131 VSSIO.t133 VSSIO.t132 nfet_03v3 ad=20.8n pd=0.504m as=20.8n ps=0.504m w=400 l=56
X120 VSSIO.t91 VSSIO.t89 PAD.t2 VSSIO.t90 nfet_03v3 ad=20.8n pd=0.504m as=20.8n ps=0.504m w=400 l=56
X121 PAD.t11 VSSIO.t116 VSSIO.t118 VSSIO.t117 nfet_03v3 ad=20.8n pd=0.504m as=20.8n ps=0.504m w=400 l=56
X122 a_n7856_9000.t64 GN.t17 VSSIO.t58 VSSIO.t57 nfet_03v3 ad=20.8n pd=0.504m as=20.8n ps=0.504m w=400 l=56
X123 VDDIO.t65 GP.t10 a_n7856_9000.t31 VDDIO.t64 pfet_03v3 ad=52n pd=1.104m as=52n ps=1.104m w=1000 l=56
X124 a_n7856_9000.t66 GN.t15 VSSIO.t29 VSSIO.t28 nfet_03v3 ad=20.8n pd=0.504m as=20.8n ps=0.504m w=400 l=56
X125 VDDIO.t37 GP.t12 a_n7856_9000.t29 VDDIO.t36 pfet_03v3 ad=52n pd=1.104m as=52n ps=1.104m w=1000 l=56
X126 VDDIO.t3 GP.t40 a_n7856_9000.t1 VDDIO.t2 pfet_03v3 ad=52n pd=1.104m as=52n ps=1.104m w=1000 l=56
X127 VSSIO.t112 VSSIO.t110 PAD.t8 VSSIO.t111 nfet_03v3 ad=20.8n pd=0.504m as=20.8n ps=0.504m w=400 l=56
X128 IN.t1 PAD.t41 VDDIO.t103 VDDIO.t102 pfet_03v3 ad=70.4n pd=1.776m as=70.4n ps=1.776m w=800 l=56
X129 a_n7856_9000.t30 GP.t11 VDDIO.t63 VDDIO.t62 pfet_03v3 ad=52n pd=1.104m as=52n ps=1.104m w=1000 l=56
X130 a_n6172_11080.t1 OUT.t1 VDDIO.t83 VDDIO.t82 pfet_03v3 ad=35.2n pd=0.976m as=35.2n ps=0.976m w=400 l=56
X131 a_n7856_9000.t22 GP.t19 VDDIO.t35 VDDIO.t34 pfet_03v3 ad=52n pd=1.104m as=52n ps=1.104m w=1000 l=56
X132 VSSIO.t31 GN.t8 a_n7856_9000.t73 VSSIO.t30 nfet_03v3 ad=20.8n pd=0.504m as=20.8n ps=0.504m w=400 l=56
X133 VSSIO.t25 GN.t36 a_n7856_9000.t45 VSSIO.t24 nfet_03v3 ad=20.8n pd=0.504m as=20.8n ps=0.504m w=400 l=56
X134 a_n6172_11080.t0 OUT.t3 VSSIO.t54 VSSIO.t53 nfet_03v3 ad=17.6n pd=0.576m as=17.6n ps=0.576m w=200 l=56
D3 PAD.t45 VDDIO.t100 diode_pd2nw_03v3 pj=6400 area=2.56e+06
X135 GP.t0 a_n972_11080.t2 VDDIO.t88 VDDIO.t87 pfet_03v3 ad=35.2n pd=0.976m as=35.2n ps=0.976m w=400 l=56
X136 VDDIO.t55 GP.t16 a_n7856_9000.t25 VDDIO.t54 pfet_03v3 ad=52n pd=1.104m as=52n ps=1.104m w=1000 l=56
X137 a_628_11080.t0 a_n4948_11920.t3 VDDIO.t81 VDDIO.t80 pfet_03v3 ad=35.2n pd=0.976m as=35.2n ps=0.976m w=400 l=56
X138 VDDIO.t51 GP.t18 a_n7856_9000.t23 VDDIO.t50 pfet_03v3 ad=52n pd=1.104m as=52n ps=1.104m w=1000 l=56
X139 a_n7856_9000.t72 GN.t9 VSSIO.t15 VSSIO.t14 nfet_03v3 ad=20.8n pd=0.504m as=20.8n ps=0.504m w=400 l=56
X140 a_n7856_9000.t50 GN.t31 VSSIO.t27 VSSIO.t26 nfet_03v3 ad=20.8n pd=0.504m as=20.8n ps=0.504m w=400 l=56
X141 a_n3172_11080.t0 a_n4948_11920.t4 VDDIO.t90 VDDIO.t89 pfet_03v3 ad=35.2n pd=0.976m as=35.2n ps=0.976m w=400 l=56
X142 a_n7856_9000.t44 GN.t37 VSSIO.t9 VSSIO.t8 nfet_03v3 ad=20.8n pd=0.504m as=20.8n ps=0.504m w=400 l=56
X143 GP.t1 a_n972_11080.t3 VSSIO.t229 VSSIO.t228 nfet_03v3 ad=17.6n pd=0.576m as=17.6n ps=0.576m w=200 l=56
X144 a_628_11920.t2 a_n4948_11920.t5 VSSIO.t60 VSSIO.t59 nfet_03v3 ad=17.6n pd=0.576m as=17.6n ps=0.576m w=200 l=56
X145 PAD.t39 VSSIO.t194 VSSIO.t196 VSSIO.t195 nfet_03v3 ad=20.8n pd=0.504m as=20.8n ps=0.504m w=400 l=56
X146 VSSIO.t97 VSSIO.t95 PAD.t6 VSSIO.t96 nfet_03v3 ad=20.8n pd=0.504m as=20.8n ps=0.504m w=400 l=56
X147 VSSIO.t11 GN.t32 a_n7856_9000.t49 VSSIO.t10 nfet_03v3 ad=20.8n pd=0.504m as=20.8n ps=0.504m w=400 l=56
X148 a_n3172_11920.t2 a_n4948_11920.t6 VSSIO.t221 VSSIO.t220 nfet_03v3 ad=17.6n pd=0.576m as=17.6n ps=0.576m w=200 l=56
R0 VSSIO.n198 VSSIO.n23 23902.5
R1 VSSIO.n68 VSSIO.n66 14754
R2 VSSIO.n122 VSSIO.n29 14754
R3 VSSIO.n124 VSSIO.n27 14754
R4 VSSIO.n156 VSSIO.n23 7184.56
R5 VSSIO.n100 VSSIO.n65 6500
R6 VSSIO.n121 VSSIO.n30 6500
R7 VSSIO.n123 VSSIO.n28 6500
R8 VSSIO.n126 VSSIO.n25 6075.16
R9 VSSIO.n119 VSSIO.n32 6075.16
R10 VSSIO.n103 VSSIO.n64 6075.16
R11 VSSIO.n71 VSSIO.n69 6075.16
R12 VSSIO.n125 VSSIO.n26 6075.16
R13 VSSIO.n120 VSSIO.n31 5939.47
R14 VSSIO.n127 VSSIO.n126 5843.71
R15 VSSIO.n197 VSSIO.n127 4905.69
R16 VSSIO.t76 VSSIO.n195 4286.02
R17 VSSIO.t65 VSSIO.n63 2878.83
R18 VSSIO.n126 VSSIO.n125 2863.44
R19 VSSIO.n121 VSSIO.n120 2747.36
R20 VSSIO.n125 VSSIO.n124 2541.3
R21 VSSIO.n124 VSSIO.n123 2505.51
R22 VSSIO.n123 VSSIO.n122 2505.51
R23 VSSIO.n122 VSSIO.n121 2505.51
R24 VSSIO.n198 VSSIO.n197 2054.5
R25 VSSIO.n196 VSSIO.t76 1721.23
R26 VSSIO.n168 VSSIO.t204 1698.67
R27 VSSIO.n127 VSSIO.n24 1499.81
R28 VSSIO.n120 VSSIO.n119 1323.82
R29 VSSIO.n198 VSSIO.t78 1089.29
R30 VSSIO.n119 VSSIO.n118 839.062
R31 VSSIO.n199 VSSIO.n198 822.636
R32 VSSIO.n200 VSSIO.n199 700.774
R33 VSSIO.n196 VSSIO.t206 439.973
R34 VSSIO.n25 VSSIO.t53 374.108
R35 VSSIO.t84 VSSIO.n26 374.108
R36 VSSIO.t80 VSSIO.n32 374.108
R37 VSSIO.t228 VSSIO.n71 374.108
R38 VSSIO.n103 VSSIO.t208 374.108
R39 VSSIO.t230 VSSIO.n31 373.075
R40 VSSIO.n82 VSSIO.n28 372.002
R41 VSSIO.t218 VSSIO.n30 363.57
R42 VSSIO.n100 VSSIO.t67 363.57
R43 VSSIO.n118 VSSIO.t6 350
R44 VSSIO.n84 VSSIO.n27 287.695
R45 VSSIO.t220 VSSIO.n29 279.264
R46 VSSIO.t59 VSSIO.n66 279.264
R47 VSSIO.t22 VSSIO.t16 250
R48 VSSIO.t16 VSSIO.t0 250
R49 VSSIO.t0 VSSIO.t8 250
R50 VSSIO.t24 VSSIO.t71 250
R51 VSSIO.t71 VSSIO.t18 250
R52 VSSIO.t18 VSSIO.t2 250
R53 VSSIO.t2 VSSIO.t10 250
R54 VSSIO.t26 VSSIO.t44 250
R55 VSSIO.t44 VSSIO.t46 250
R56 VSSIO.t46 VSSIO.t212 250
R57 VSSIO.t48 VSSIO.t55 250
R58 VSSIO.t55 VSSIO.t32 250
R59 VSSIO.t32 VSSIO.t40 250
R60 VSSIO.t40 VSSIO.t222 250
R61 VSSIO.t222 VSSIO.t61 250
R62 VSSIO.t61 VSSIO.t214 250
R63 VSSIO.t214 VSSIO.t50 250
R64 VSSIO.t50 VSSIO.t20 250
R65 VSSIO.t57 VSSIO.t4 250
R66 VSSIO.t12 VSSIO.t57 250
R67 VSSIO.t28 VSSIO.t12 250
R68 VSSIO.t34 VSSIO.t28 250
R69 VSSIO.t42 VSSIO.t34 250
R70 VSSIO.t224 VSSIO.t42 250
R71 VSSIO.t63 VSSIO.t224 250
R72 VSSIO.t210 VSSIO.t63 250
R73 VSSIO.t14 VSSIO.t210 250
R74 VSSIO.t30 VSSIO.t14 250
R75 VSSIO.t36 VSSIO.t30 250
R76 VSSIO.t226 VSSIO.t36 250
R77 VSSIO.t216 VSSIO.t226 250
R78 VSSIO.t38 VSSIO.t82 250
R79 VSSIO.t82 VSSIO.t73 250
R80 VSSIO.t212 VSSIO.n64 248.439
R81 VSSIO.t53 VSSIO.n24 236.058
R82 VSSIO.n85 VSSIO.t84 236.058
R83 VSSIO.n84 VSSIO.t52 236.058
R84 VSSIO.n82 VSSIO.t69 236.058
R85 VSSIO.n80 VSSIO.t220 236.058
R86 VSSIO.n78 VSSIO.t218 236.058
R87 VSSIO.n76 VSSIO.t230 236.058
R88 VSSIO.n74 VSSIO.t80 236.058
R89 VSSIO.n72 VSSIO.t228 236.058
R90 VSSIO.n70 VSSIO.t59 236.058
R91 VSSIO.t67 VSSIO.n99 236.058
R92 VSSIO.t208 VSSIO.n102 236.058
R93 VSSIO.n104 VSSIO.t65 236.058
R94 VSSIO.n65 VSSIO.t26 235.939
R95 VSSIO.n85 VSSIO.n25 232.897
R96 VSSIO.n72 VSSIO.n32 232.897
R97 VSSIO.n71 VSSIO.n70 232.897
R98 VSSIO.n104 VSSIO.n103 232.897
R99 VSSIO.n74 VSSIO.n31 231.821
R100 VSSIO.t52 VSSIO.n26 224.465
R101 VSSIO.n199 VSSIO.t20 223.439
R102 VSSIO.n80 VSSIO.n28 222.357
R103 VSSIO.n76 VSSIO.n30 222.357
R104 VSSIO.n102 VSSIO.n100 222.357
R105 VSSIO.n63 VSSIO.t216 195.312
R106 VSSIO.n69 VSSIO.t22 189.062
R107 VSSIO.t8 VSSIO.n68 170.312
R108 VSSIO.n156 VSSIO.t147 170.024
R109 VSSIO.n78 VSSIO.n29 138.052
R110 VSSIO.n99 VSSIO.n66 138.052
R111 VSSIO.t69 VSSIO.n27 129.621
R112 VSSIO.n157 VSSIO.n156 128.917
R113 VSSIO.n157 VSSIO.t150 121.334
R114 VSSIO.n168 VSSIO.t78 121.334
R115 VSSIO.n200 VSSIO.t75 101.365
R116 VSSIO.t90 VSSIO.t87 97.8552
R117 VSSIO.t102 VSSIO.t90 97.8552
R118 VSSIO.t105 VSSIO.t102 97.8552
R119 VSSIO.t99 VSSIO.t105 97.8552
R120 VSSIO.t96 VSSIO.t99 97.8552
R121 VSSIO.t108 VSSIO.t96 97.8552
R122 VSSIO.t111 VSSIO.t108 97.8552
R123 VSSIO.t114 VSSIO.t111 97.8552
R124 VSSIO.t120 VSSIO.t114 97.8552
R125 VSSIO.t117 VSSIO.t120 97.8552
R126 VSSIO.t123 VSSIO.t117 97.8552
R127 VSSIO.t129 VSSIO.t123 97.8552
R128 VSSIO.t135 VSSIO.t129 97.8552
R129 VSSIO.t138 VSSIO.t135 97.8552
R130 VSSIO.t141 VSSIO.t138 97.8552
R131 VSSIO.t132 VSSIO.t141 97.8552
R132 VSSIO.t126 VSSIO.t132 97.8552
R133 VSSIO.t144 VSSIO.t126 97.8552
R134 VSSIO.t147 VSSIO.t144 97.8552
R135 VSSIO.t150 VSSIO.t93 86.6672
R136 VSSIO.t93 VSSIO.t153 86.6672
R137 VSSIO.t153 VSSIO.t156 86.6672
R138 VSSIO.t156 VSSIO.t159 86.6672
R139 VSSIO.t159 VSSIO.t162 86.6672
R140 VSSIO.t162 VSSIO.t165 86.6672
R141 VSSIO.t165 VSSIO.t171 86.6672
R142 VSSIO.t171 VSSIO.t168 86.6672
R143 VSSIO.t168 VSSIO.t174 86.6672
R144 VSSIO.t174 VSSIO.t177 86.6672
R145 VSSIO.t177 VSSIO.t183 86.6672
R146 VSSIO.t183 VSSIO.t186 86.6672
R147 VSSIO.t186 VSSIO.t180 86.6672
R148 VSSIO.t180 VSSIO.t189 86.6672
R149 VSSIO.t189 VSSIO.t192 86.6672
R150 VSSIO.t192 VSSIO.t198 86.6672
R151 VSSIO.t198 VSSIO.t201 86.6672
R152 VSSIO.t204 VSSIO.t195 86.6672
R153 VSSIO.n195 VSSIO.n194 79.9969
R154 VSSIO.n68 VSSIO.t24 79.688
R155 VSSIO.n69 VSSIO.t6 60.938
R156 VSSIO.n195 VSSIO.t87 59.9365
R157 VSSIO.t201 VSSIO.n23 55.7922
R158 VSSIO.n63 VSSIO.t38 54.688
R159 VSSIO.n137 VSSIO.t203 44.2698
R160 VSSIO.n2 VSSIO.t146 44.2698
R161 VSSIO.n21 VSSIO.n20 43.0442
R162 VSSIO.n182 VSSIO.n155 42.7878
R163 VSSIO.n197 VSSIO.n196 33.4523
R164 VSSIO.n202 VSSIO.n201 33.233
R165 VSSIO.n137 VSSIO.t194 32.5898
R166 VSSIO.n138 VSSIO.t200 32.5898
R167 VSSIO.n139 VSSIO.t197 32.5898
R168 VSSIO.n140 VSSIO.t191 32.5898
R169 VSSIO.n141 VSSIO.t188 32.5898
R170 VSSIO.n142 VSSIO.t179 32.5898
R171 VSSIO.n143 VSSIO.t185 32.5898
R172 VSSIO.n144 VSSIO.t182 32.5898
R173 VSSIO.n145 VSSIO.t176 32.5898
R174 VSSIO.n146 VSSIO.t173 32.5898
R175 VSSIO.n147 VSSIO.t167 32.5898
R176 VSSIO.n148 VSSIO.t170 32.5898
R177 VSSIO.n149 VSSIO.t164 32.5898
R178 VSSIO.n150 VSSIO.t161 32.5898
R179 VSSIO.n151 VSSIO.t158 32.5898
R180 VSSIO.n152 VSSIO.t155 32.5898
R181 VSSIO.n153 VSSIO.t152 32.5898
R182 VSSIO.n154 VSSIO.t92 32.5898
R183 VSSIO.n155 VSSIO.t149 32.5898
R184 VSSIO.n2 VSSIO.t143 32.5898
R185 VSSIO.n3 VSSIO.t125 32.5898
R186 VSSIO.n4 VSSIO.t131 32.5898
R187 VSSIO.n5 VSSIO.t140 32.5898
R188 VSSIO.n6 VSSIO.t137 32.5898
R189 VSSIO.n7 VSSIO.t134 32.5898
R190 VSSIO.n8 VSSIO.t128 32.5898
R191 VSSIO.n9 VSSIO.t122 32.5898
R192 VSSIO.n10 VSSIO.t116 32.5898
R193 VSSIO.n11 VSSIO.t119 32.5898
R194 VSSIO.n12 VSSIO.t113 32.5898
R195 VSSIO.n13 VSSIO.t110 32.5898
R196 VSSIO.n14 VSSIO.t107 32.5898
R197 VSSIO.n15 VSSIO.t95 32.5898
R198 VSSIO.n16 VSSIO.t98 32.5898
R199 VSSIO.n17 VSSIO.t104 32.5898
R200 VSSIO.n18 VSSIO.t101 32.5898
R201 VSSIO.n19 VSSIO.t89 32.5898
R202 VSSIO.n20 VSSIO.t86 32.5898
R203 VSSIO.t195 VSSIO.n23 30.8755
R204 VSSIO.n199 VSSIO.t4 26.563
R205 VSSIO.n107 VSSIO.n106 16.8827
R206 VSSIO.t10 VSSIO.n65 14.063
R207 VSSIO.n201 VSSIO.n22 13.595
R208 VSSIO.n201 VSSIO 12.4655
R209 VSSIO.n155 VSSIO.n154 11.6805
R210 VSSIO.n154 VSSIO.n153 11.6805
R211 VSSIO.n153 VSSIO.n152 11.6805
R212 VSSIO.n152 VSSIO.n151 11.6805
R213 VSSIO.n151 VSSIO.n150 11.6805
R214 VSSIO.n150 VSSIO.n149 11.6805
R215 VSSIO.n149 VSSIO.n148 11.6805
R216 VSSIO.n148 VSSIO.n147 11.6805
R217 VSSIO.n147 VSSIO.n146 11.6805
R218 VSSIO.n146 VSSIO.n145 11.6805
R219 VSSIO.n145 VSSIO.n144 11.6805
R220 VSSIO.n144 VSSIO.n143 11.6805
R221 VSSIO.n143 VSSIO.n142 11.6805
R222 VSSIO.n142 VSSIO.n141 11.6805
R223 VSSIO.n141 VSSIO.n140 11.6805
R224 VSSIO.n140 VSSIO.n139 11.6805
R225 VSSIO.n139 VSSIO.n138 11.6805
R226 VSSIO.n138 VSSIO.n137 11.6805
R227 VSSIO.n20 VSSIO.n19 11.6805
R228 VSSIO.n19 VSSIO.n18 11.6805
R229 VSSIO.n18 VSSIO.n17 11.6805
R230 VSSIO.n17 VSSIO.n16 11.6805
R231 VSSIO.n16 VSSIO.n15 11.6805
R232 VSSIO.n15 VSSIO.n14 11.6805
R233 VSSIO.n14 VSSIO.n13 11.6805
R234 VSSIO.n13 VSSIO.n12 11.6805
R235 VSSIO.n12 VSSIO.n11 11.6805
R236 VSSIO.n11 VSSIO.n10 11.6805
R237 VSSIO.n10 VSSIO.n9 11.6805
R238 VSSIO.n9 VSSIO.n8 11.6805
R239 VSSIO.n8 VSSIO.n7 11.6805
R240 VSSIO.n7 VSSIO.n6 11.6805
R241 VSSIO.n6 VSSIO.n5 11.6805
R242 VSSIO.n5 VSSIO.n4 11.6805
R243 VSSIO.n4 VSSIO.n3 11.6805
R244 VSSIO.n3 VSSIO.n2 11.6805
R245 VSSIO.n1 VSSIO 9.2345
R246 VSSIO.n0 VSSIO 8.0555
R247 VSSIO.n22 VSSIO.t74 7.3895
R248 VSSIO.n183 VSSIO.t148 7.277
R249 VSSIO.n171 VSSIO.t205 7.277
R250 VSSIO.n52 VSSIO.n51 6.53225
R251 VSSIO.n53 VSSIO.n50 6.53225
R252 VSSIO.n54 VSSIO.n49 6.53225
R253 VSSIO.n55 VSSIO.n48 6.53225
R254 VSSIO.n56 VSSIO.n47 6.53225
R255 VSSIO.n57 VSSIO.n46 6.53225
R256 VSSIO.n58 VSSIO.n45 6.53225
R257 VSSIO.n59 VSSIO.n44 6.53225
R258 VSSIO.n60 VSSIO.n43 6.53225
R259 VSSIO.n61 VSSIO.n42 6.53225
R260 VSSIO.n108 VSSIO.n41 6.53225
R261 VSSIO.n109 VSSIO.n40 6.53225
R262 VSSIO.n110 VSSIO.n39 6.53225
R263 VSSIO.n111 VSSIO.n38 6.53225
R264 VSSIO.n112 VSSIO.n37 6.53225
R265 VSSIO.n113 VSSIO.n36 6.53225
R266 VSSIO.n114 VSSIO.n35 6.53225
R267 VSSIO.n115 VSSIO.n34 6.53225
R268 VSSIO.n116 VSSIO.n33 6.53225
R269 VSSIO.n184 VSSIO.n136 6.458
R270 VSSIO.n185 VSSIO.n135 6.458
R271 VSSIO.n186 VSSIO.n134 6.458
R272 VSSIO.n187 VSSIO.n133 6.458
R273 VSSIO.n188 VSSIO.n132 6.458
R274 VSSIO.n189 VSSIO.n131 6.458
R275 VSSIO.n190 VSSIO.n130 6.458
R276 VSSIO.n191 VSSIO.n129 6.458
R277 VSSIO.n192 VSSIO.n128 6.458
R278 VSSIO.n172 VSSIO.n167 6.458
R279 VSSIO.n173 VSSIO.n166 6.458
R280 VSSIO.n174 VSSIO.n165 6.458
R281 VSSIO.n175 VSSIO.n164 6.458
R282 VSSIO.n176 VSSIO.n163 6.458
R283 VSSIO.n177 VSSIO.n162 6.458
R284 VSSIO.n178 VSSIO.n161 6.458
R285 VSSIO.n179 VSSIO.n160 6.458
R286 VSSIO.n180 VSSIO.n159 6.458
R287 VSSIO.n89 VSSIO.n84 5.66277
R288 VSSIO.n0 VSSIO 5.5355
R289 VSSIO.n87 VSSIO.n24 5.2005
R290 VSSIO.n86 VSSIO.n85 5.2005
R291 VSSIO.n83 VSSIO.n82 5.2005
R292 VSSIO.n81 VSSIO.n80 5.2005
R293 VSSIO.n79 VSSIO.n78 5.2005
R294 VSSIO.n77 VSSIO.n76 5.2005
R295 VSSIO.n75 VSSIO.n74 5.2005
R296 VSSIO.n73 VSSIO.n72 5.2005
R297 VSSIO.n70 VSSIO.n67 5.2005
R298 VSSIO.n99 VSSIO.n98 5.2005
R299 VSSIO.n102 VSSIO.n101 5.2005
R300 VSSIO.n105 VSSIO.n104 5.2005
R301 VSSIO.n170 VSSIO.n169 5.1222
R302 VSSIO.n117 VSSIO 4.9595
R303 VSSIO.n105 VSSIO.t66 4.901
R304 VSSIO.n101 VSSIO.t209 4.901
R305 VSSIO.n98 VSSIO.t68 4.901
R306 VSSIO.n67 VSSIO.t60 4.901
R307 VSSIO.n73 VSSIO.t229 4.901
R308 VSSIO.n75 VSSIO.t81 4.901
R309 VSSIO.n77 VSSIO.t231 4.901
R310 VSSIO.n79 VSSIO.t219 4.901
R311 VSSIO.n81 VSSIO.t221 4.901
R312 VSSIO.n83 VSSIO.t70 4.901
R313 VSSIO.n86 VSSIO.t85 4.901
R314 VSSIO.n87 VSSIO.t54 4.901
R315 VSSIO.n194 VSSIO.n193 4.883
R316 VSSIO.n181 VSSIO.n158 4.883
R317 VSSIO.n171 VSSIO.n170 3.61654
R318 VSSIO.n169 VSSIO.n168 2.93626
R319 VSSIO.n158 VSSIO.n157 2.93626
R320 VSSIO.n118 VSSIO.n117 2.93626
R321 VSSIO.n158 VSSIO.t151 2.3945
R322 VSSIO.n169 VSSIO.t79 2.3945
R323 VSSIO.n117 VSSIO.t7 2.3945
R324 VSSIO.n194 VSSIO.t88 2.3945
R325 VSSIO.n1 VSSIO.n0 2.3405
R326 VSSIO.n64 VSSIO.t48 1.563
R327 VSSIO VSSIO.n1 1.4405
R328 VSSIO.n88 VSSIO.n87 1.06277
R329 VSSIO.n202 VSSIO.n21 0.9995
R330 VSSIO.n136 VSSIO.t127 0.8195
R331 VSSIO.n136 VSSIO.t145 0.8195
R332 VSSIO.n135 VSSIO.t142 0.8195
R333 VSSIO.n135 VSSIO.t133 0.8195
R334 VSSIO.n134 VSSIO.t136 0.8195
R335 VSSIO.n134 VSSIO.t139 0.8195
R336 VSSIO.n133 VSSIO.t124 0.8195
R337 VSSIO.n133 VSSIO.t130 0.8195
R338 VSSIO.n132 VSSIO.t121 0.8195
R339 VSSIO.n132 VSSIO.t118 0.8195
R340 VSSIO.n131 VSSIO.t112 0.8195
R341 VSSIO.n131 VSSIO.t115 0.8195
R342 VSSIO.n130 VSSIO.t97 0.8195
R343 VSSIO.n130 VSSIO.t109 0.8195
R344 VSSIO.n129 VSSIO.t106 0.8195
R345 VSSIO.n129 VSSIO.t100 0.8195
R346 VSSIO.n128 VSSIO.t91 0.8195
R347 VSSIO.n128 VSSIO.t103 0.8195
R348 VSSIO.n167 VSSIO.t202 0.8195
R349 VSSIO.n167 VSSIO.t196 0.8195
R350 VSSIO.n166 VSSIO.t193 0.8195
R351 VSSIO.n166 VSSIO.t199 0.8195
R352 VSSIO.n165 VSSIO.t181 0.8195
R353 VSSIO.n165 VSSIO.t190 0.8195
R354 VSSIO.n164 VSSIO.t184 0.8195
R355 VSSIO.n164 VSSIO.t187 0.8195
R356 VSSIO.n163 VSSIO.t175 0.8195
R357 VSSIO.n163 VSSIO.t178 0.8195
R358 VSSIO.n162 VSSIO.t172 0.8195
R359 VSSIO.n162 VSSIO.t169 0.8195
R360 VSSIO.n161 VSSIO.t163 0.8195
R361 VSSIO.n161 VSSIO.t166 0.8195
R362 VSSIO.n160 VSSIO.t157 0.8195
R363 VSSIO.n160 VSSIO.t160 0.8195
R364 VSSIO.n159 VSSIO.t94 0.8195
R365 VSSIO.n159 VSSIO.t154 0.8195
R366 VSSIO.n51 VSSIO.t39 0.8195
R367 VSSIO.n51 VSSIO.t83 0.8195
R368 VSSIO.n50 VSSIO.t227 0.8195
R369 VSSIO.n50 VSSIO.t217 0.8195
R370 VSSIO.n49 VSSIO.t31 0.8195
R371 VSSIO.n49 VSSIO.t37 0.8195
R372 VSSIO.n48 VSSIO.t211 0.8195
R373 VSSIO.n48 VSSIO.t15 0.8195
R374 VSSIO.n47 VSSIO.t225 0.8195
R375 VSSIO.n47 VSSIO.t64 0.8195
R376 VSSIO.n46 VSSIO.t35 0.8195
R377 VSSIO.n46 VSSIO.t43 0.8195
R378 VSSIO.n45 VSSIO.t13 0.8195
R379 VSSIO.n45 VSSIO.t29 0.8195
R380 VSSIO.n44 VSSIO.t5 0.8195
R381 VSSIO.n44 VSSIO.t58 0.8195
R382 VSSIO.n43 VSSIO.t51 0.8195
R383 VSSIO.n43 VSSIO.t21 0.8195
R384 VSSIO.n42 VSSIO.t62 0.8195
R385 VSSIO.n42 VSSIO.t215 0.8195
R386 VSSIO.n41 VSSIO.t41 0.8195
R387 VSSIO.n41 VSSIO.t223 0.8195
R388 VSSIO.n40 VSSIO.t56 0.8195
R389 VSSIO.n40 VSSIO.t33 0.8195
R390 VSSIO.n39 VSSIO.t213 0.8195
R391 VSSIO.n39 VSSIO.t49 0.8195
R392 VSSIO.n38 VSSIO.t45 0.8195
R393 VSSIO.n38 VSSIO.t47 0.8195
R394 VSSIO.n37 VSSIO.t11 0.8195
R395 VSSIO.n37 VSSIO.t27 0.8195
R396 VSSIO.n36 VSSIO.t19 0.8195
R397 VSSIO.n36 VSSIO.t3 0.8195
R398 VSSIO.n35 VSSIO.t25 0.8195
R399 VSSIO.n35 VSSIO.t72 0.8195
R400 VSSIO.n34 VSSIO.t1 0.8195
R401 VSSIO.n34 VSSIO.t9 0.8195
R402 VSSIO.n33 VSSIO.t23 0.8195
R403 VSSIO.n33 VSSIO.t17 0.8195
R404 VSSIO.n89 VSSIO.n88 0.7625
R405 VSSIO.n94 VSSIO.n93 0.6005
R406 VSSIO.n95 VSSIO.n94 0.6005
R407 VSSIO.n96 VSSIO.n95 0.6005
R408 VSSIO.n106 VSSIO.n62 0.6005
R409 VSSIO.n93 VSSIO.n92 0.5855
R410 VSSIO.n97 VSSIO.n62 0.5855
R411 VSSIO.n90 VSSIO.n89 0.4655
R412 VSSIO.n92 VSSIO.n91 0.4655
R413 VSSIO.n97 VSSIO.n96 0.4655
R414 VSSIO.n106 VSSIO.n105 0.462773
R415 VSSIO.n101 VSSIO.n62 0.462773
R416 VSSIO.n98 VSSIO.n97 0.462773
R417 VSSIO.n96 VSSIO.n67 0.462773
R418 VSSIO.n95 VSSIO.n73 0.462773
R419 VSSIO.n94 VSSIO.n75 0.462773
R420 VSSIO.n93 VSSIO.n77 0.462773
R421 VSSIO.n92 VSSIO.n79 0.462773
R422 VSSIO.n91 VSSIO.n81 0.462773
R423 VSSIO.n90 VSSIO.n83 0.462773
R424 VSSIO.n88 VSSIO.n86 0.462773
R425 VSSIO.n91 VSSIO.n90 0.4235
R426 VSSIO.n116 VSSIO.n115 0.3605
R427 VSSIO.n115 VSSIO.n114 0.3605
R428 VSSIO.n114 VSSIO.n113 0.3605
R429 VSSIO.n113 VSSIO.n112 0.3605
R430 VSSIO.n112 VSSIO.n111 0.3605
R431 VSSIO.n111 VSSIO.n110 0.3605
R432 VSSIO.n110 VSSIO.n109 0.3605
R433 VSSIO.n109 VSSIO.n108 0.3605
R434 VSSIO.n61 VSSIO.n60 0.3605
R435 VSSIO.n60 VSSIO.n59 0.3605
R436 VSSIO.n59 VSSIO.n58 0.3605
R437 VSSIO.n58 VSSIO.n57 0.3605
R438 VSSIO.n57 VSSIO.n56 0.3605
R439 VSSIO.n56 VSSIO.n55 0.3605
R440 VSSIO.n55 VSSIO.n54 0.3605
R441 VSSIO.n54 VSSIO.n53 0.3605
R442 VSSIO.n53 VSSIO.n52 0.3605
R443 VSSIO VSSIO.n116 0.35825
R444 VSSIO.n52 VSSIO.n22 0.32225
R445 VSSIO.n108 VSSIO.n107 0.32
R446 VSSIO.n182 VSSIO.n181 0.232281
R447 VSSIO VSSIO.n200 0.221777
R448 VSSIO.n193 VSSIO.n192 0.19776
R449 VSSIO.n192 VSSIO.n191 0.19776
R450 VSSIO.n191 VSSIO.n190 0.19776
R451 VSSIO.n190 VSSIO.n189 0.19776
R452 VSSIO.n189 VSSIO.n188 0.19776
R453 VSSIO.n188 VSSIO.n187 0.19776
R454 VSSIO.n187 VSSIO.n186 0.19776
R455 VSSIO.n186 VSSIO.n185 0.19776
R456 VSSIO.n185 VSSIO.n184 0.19776
R457 VSSIO.n184 VSSIO.n183 0.19776
R458 VSSIO.n181 VSSIO.n180 0.19776
R459 VSSIO.n180 VSSIO.n179 0.19776
R460 VSSIO.n179 VSSIO.n178 0.19776
R461 VSSIO.n178 VSSIO.n177 0.19776
R462 VSSIO.n177 VSSIO.n176 0.19776
R463 VSSIO.n176 VSSIO.n175 0.19776
R464 VSSIO.n175 VSSIO.n174 0.19776
R465 VSSIO.n174 VSSIO.n173 0.19776
R466 VSSIO.n173 VSSIO.n172 0.19776
R467 VSSIO.n172 VSSIO.n171 0.19776
R468 VSSIO.n183 VSSIO.n182 0.189315
R469 VSSIO.n193 VSSIO.n21 0.121322
R470 VSSIO VSSIO.n202 0.1085
R471 VSSIO.n107 VSSIO.n61 0.041
R472 VSSIO.n170 VSSIO 0.0272021
R473 VSSIO VSSIO.t232 0.0122914
R474 IN IN.t0 9.17375
R475 IN IN.t1 8.13509
R476 PAD.n54 PAD.t41 108.495
R477 PAD.n54 PAD.t42 75.5435
R478 PAD.n41 PAD.n21 10.6494
R479 PAD.n55 PAD.n54 10.1705
R480 PAD.n104 PAD 7.7513
R481 PAD.n102 PAD 7.54362
R482 PAD.n31 PAD.n30 7.02725
R483 PAD.n18 PAD.n17 7.02725
R484 PAD.n9 PAD.n8 7.02725
R485 PAD.n41 PAD.n40 6.97229
R486 PAD.n40 PAD.n39 6.89675
R487 PAD.n38 PAD.n22 6.66725
R488 PAD.n37 PAD.n23 6.66725
R489 PAD.n36 PAD.n24 6.66725
R490 PAD.n35 PAD.n25 6.66725
R491 PAD.n34 PAD.n26 6.66725
R492 PAD.n33 PAD.n27 6.66725
R493 PAD.n32 PAD.n28 6.66725
R494 PAD.n31 PAD.n29 6.66725
R495 PAD.n18 PAD.n16 6.66725
R496 PAD.n19 PAD.n15 6.66725
R497 PAD.n20 PAD.n14 6.66725
R498 PAD.n13 PAD.n3 6.66725
R499 PAD.n12 PAD.n4 6.66725
R500 PAD.n11 PAD.n5 6.66725
R501 PAD.n10 PAD.n6 6.66725
R502 PAD.n9 PAD.n7 6.66725
R503 PAD.n57 PAD.n55 4.5005
R504 PAD.n195 PAD.n41 2.03232
R505 PAD PAD.n198 1.3199
R506 PAD.n198 PAD 1.3199
R507 PAD.n198 PAD 1.3199
R508 PAD.n39 PAD.t21 0.8195
R509 PAD.n39 PAD.t22 0.8195
R510 PAD.n22 PAD.t23 0.8195
R511 PAD.n22 PAD.t24 0.8195
R512 PAD.n23 PAD.t25 0.8195
R513 PAD.n23 PAD.t26 0.8195
R514 PAD.n24 PAD.t27 0.8195
R515 PAD.n24 PAD.t28 0.8195
R516 PAD.n25 PAD.t29 0.8195
R517 PAD.n25 PAD.t30 0.8195
R518 PAD.n26 PAD.t31 0.8195
R519 PAD.n26 PAD.t32 0.8195
R520 PAD.n27 PAD.t33 0.8195
R521 PAD.n27 PAD.t34 0.8195
R522 PAD.n28 PAD.t35 0.8195
R523 PAD.n28 PAD.t36 0.8195
R524 PAD.n29 PAD.t37 0.8195
R525 PAD.n29 PAD.t38 0.8195
R526 PAD.n30 PAD.t39 0.8195
R527 PAD.n30 PAD.t40 0.8195
R528 PAD.n17 PAD.t1 0.8195
R529 PAD.n17 PAD.t2 0.8195
R530 PAD.n16 PAD.t3 0.8195
R531 PAD.n16 PAD.t4 0.8195
R532 PAD.n15 PAD.t5 0.8195
R533 PAD.n15 PAD.t6 0.8195
R534 PAD.n14 PAD.t7 0.8195
R535 PAD.n14 PAD.t8 0.8195
R536 PAD.n3 PAD.t9 0.8195
R537 PAD.n3 PAD.t10 0.8195
R538 PAD.n4 PAD.t11 0.8195
R539 PAD.n4 PAD.t12 0.8195
R540 PAD.n5 PAD.t13 0.8195
R541 PAD.n5 PAD.t14 0.8195
R542 PAD.n6 PAD.t15 0.8195
R543 PAD.n6 PAD.t16 0.8195
R544 PAD.n7 PAD.t17 0.8195
R545 PAD.n7 PAD.t18 0.8195
R546 PAD.n8 PAD.t19 0.8195
R547 PAD.n8 PAD.t20 0.8195
R548 PAD.n38 PAD.n37 0.3605
R549 PAD.n37 PAD.n36 0.3605
R550 PAD.n36 PAD.n35 0.3605
R551 PAD.n35 PAD.n34 0.3605
R552 PAD.n34 PAD.n33 0.3605
R553 PAD.n33 PAD.n32 0.3605
R554 PAD.n32 PAD.n31 0.3605
R555 PAD.n19 PAD.n18 0.3605
R556 PAD.n20 PAD.n19 0.3605
R557 PAD.n13 PAD.n12 0.3605
R558 PAD.n12 PAD.n11 0.3605
R559 PAD.n11 PAD.n10 0.3605
R560 PAD.n10 PAD.n9 0.3605
R561 PAD.n21 PAD.n13 0.3335
R562 PAD PAD.t0 0.280213
R563 PAD.n195 PAD.n194 0.143024
R564 PAD.n109 PAD.n102 0.143024
R565 PAD.n103 PAD.n102 0.141125
R566 PAD.n196 PAD.n195 0.141125
R567 PAD.n2 PAD.n1 0.141125
R568 PAD.n191 PAD.n190 0.141125
R569 PAD.n46 PAD.n45 0.141125
R570 PAD.n186 PAD.n185 0.141125
R571 PAD.n49 PAD.n48 0.141125
R572 PAD.n179 PAD.n178 0.141125
R573 PAD.n56 PAD.n53 0.141125
R574 PAD.n174 PAD.n173 0.141125
R575 PAD.n60 PAD.n59 0.141125
R576 PAD.n167 PAD.n166 0.141125
R577 PAD.n65 PAD.n64 0.141125
R578 PAD.n162 PAD.n161 0.141125
R579 PAD.n68 PAD.n67 0.141125
R580 PAD.n155 PAD.n154 0.141125
R581 PAD.n73 PAD.n72 0.141125
R582 PAD.n150 PAD.n149 0.141125
R583 PAD.n76 PAD.n75 0.141125
R584 PAD.n143 PAD.n142 0.141125
R585 PAD.n81 PAD.n80 0.141125
R586 PAD.n138 PAD.n137 0.141125
R587 PAD.n84 PAD.n83 0.141125
R588 PAD.n131 PAD.n130 0.141125
R589 PAD.n89 PAD.n88 0.141125
R590 PAD.n126 PAD.n125 0.141125
R591 PAD.n92 PAD.n91 0.141125
R592 PAD.n119 PAD.n118 0.141125
R593 PAD.n97 PAD.n96 0.141125
R594 PAD.n114 PAD.n113 0.141125
R595 PAD.n100 PAD.n99 0.141125
R596 PAD.n107 PAD.n106 0.141125
R597 PAD.n106 PAD.n105 0.141125
R598 PAD.n99 PAD.n98 0.141125
R599 PAD.n115 PAD.n114 0.141125
R600 PAD.n116 PAD.n97 0.141125
R601 PAD.n118 PAD.n117 0.141125
R602 PAD.n91 PAD.n90 0.141125
R603 PAD.n127 PAD.n126 0.141125
R604 PAD.n128 PAD.n89 0.141125
R605 PAD.n130 PAD.n129 0.141125
R606 PAD.n83 PAD.n82 0.141125
R607 PAD.n139 PAD.n138 0.141125
R608 PAD.n140 PAD.n81 0.141125
R609 PAD.n142 PAD.n141 0.141125
R610 PAD.n75 PAD.n74 0.141125
R611 PAD.n151 PAD.n150 0.141125
R612 PAD.n152 PAD.n73 0.141125
R613 PAD.n154 PAD.n153 0.141125
R614 PAD.n67 PAD.n66 0.141125
R615 PAD.n163 PAD.n162 0.141125
R616 PAD.n164 PAD.n65 0.141125
R617 PAD.n166 PAD.n165 0.141125
R618 PAD.n59 PAD.n58 0.141125
R619 PAD.n175 PAD.n174 0.141125
R620 PAD.n176 PAD.n56 0.141125
R621 PAD.n178 PAD.n177 0.141125
R622 PAD.n48 PAD.n47 0.141125
R623 PAD.n187 PAD.n186 0.141125
R624 PAD.n188 PAD.n46 0.141125
R625 PAD.n190 PAD.n189 0.141125
R626 PAD.n1 PAD.n0 0.141125
R627 PAD.n197 PAD.n196 0.141125
R628 PAD.n42 PAD.n2 0.141125
R629 PAD.n192 PAD.n191 0.141125
R630 PAD.n45 PAD.n44 0.141125
R631 PAD.n185 PAD.n184 0.141125
R632 PAD.n50 PAD.n49 0.141125
R633 PAD.n180 PAD.n179 0.141125
R634 PAD.n53 PAD.n52 0.141125
R635 PAD.n173 PAD.n172 0.141125
R636 PAD.n61 PAD.n60 0.141125
R637 PAD.n168 PAD.n167 0.141125
R638 PAD.n64 PAD.n63 0.141125
R639 PAD.n161 PAD.n160 0.141125
R640 PAD.n69 PAD.n68 0.141125
R641 PAD.n156 PAD.n155 0.141125
R642 PAD.n72 PAD.n71 0.141125
R643 PAD.n149 PAD.n148 0.141125
R644 PAD.n77 PAD.n76 0.141125
R645 PAD.n144 PAD.n143 0.141125
R646 PAD.n80 PAD.n79 0.141125
R647 PAD.n137 PAD.n136 0.141125
R648 PAD.n85 PAD.n84 0.141125
R649 PAD.n132 PAD.n131 0.141125
R650 PAD.n88 PAD.n87 0.141125
R651 PAD.n125 PAD.n124 0.141125
R652 PAD.n93 PAD.n92 0.141125
R653 PAD.n120 PAD.n119 0.141125
R654 PAD.n96 PAD.n95 0.141125
R655 PAD.n113 PAD.n112 0.141125
R656 PAD.n101 PAD.n100 0.141125
R657 PAD.n108 PAD.n107 0.141125
R658 PAD.n193 PAD.n192 0.141125
R659 PAD.n44 PAD.n43 0.141125
R660 PAD.n184 PAD.n183 0.141125
R661 PAD.n182 PAD.n50 0.141125
R662 PAD.n181 PAD.n180 0.141125
R663 PAD.n52 PAD.n51 0.141125
R664 PAD.n172 PAD.n171 0.141125
R665 PAD.n170 PAD.n61 0.141125
R666 PAD.n169 PAD.n168 0.141125
R667 PAD.n63 PAD.n62 0.141125
R668 PAD.n160 PAD.n159 0.141125
R669 PAD.n158 PAD.n69 0.141125
R670 PAD.n157 PAD.n156 0.141125
R671 PAD.n71 PAD.n70 0.141125
R672 PAD.n148 PAD.n147 0.141125
R673 PAD.n146 PAD.n77 0.141125
R674 PAD.n145 PAD.n144 0.141125
R675 PAD.n79 PAD.n78 0.141125
R676 PAD.n136 PAD.n135 0.141125
R677 PAD.n134 PAD.n85 0.141125
R678 PAD.n133 PAD.n132 0.141125
R679 PAD.n87 PAD.n86 0.141125
R680 PAD.n124 PAD.n123 0.141125
R681 PAD.n122 PAD.n93 0.141125
R682 PAD.n121 PAD.n120 0.141125
R683 PAD.n95 PAD.n94 0.141125
R684 PAD.n112 PAD.n111 0.141125
R685 PAD.n110 PAD.n101 0.141125
R686 PAD.n105 PAD.n104 0.140157
R687 PAD.n40 PAD.n38 0.131
R688 PAD.n194 PAD.n193 0.0721774
R689 PAD.n110 PAD.n109 0.0721774
R690 PAD.n21 PAD.n20 0.0275
R691 PAD PAD.t43 0.0251094
R692 PAD PAD.t44 0.0251094
R693 PAD PAD.t45 0.0208125
R694 PAD.n196 PAD.n1 0.0033125
R695 PAD.n190 PAD.n1 0.0033125
R696 PAD.n190 PAD.n46 0.0033125
R697 PAD.n186 PAD.n46 0.0033125
R698 PAD.n186 PAD.n48 0.0033125
R699 PAD.n178 PAD.n56 0.0033125
R700 PAD.n174 PAD.n56 0.0033125
R701 PAD.n174 PAD.n59 0.0033125
R702 PAD.n166 PAD.n59 0.0033125
R703 PAD.n166 PAD.n65 0.0033125
R704 PAD.n162 PAD.n65 0.0033125
R705 PAD.n162 PAD.n67 0.0033125
R706 PAD.n154 PAD.n67 0.0033125
R707 PAD.n154 PAD.n73 0.0033125
R708 PAD.n150 PAD.n73 0.0033125
R709 PAD.n150 PAD.n75 0.0033125
R710 PAD.n142 PAD.n75 0.0033125
R711 PAD.n142 PAD.n81 0.0033125
R712 PAD.n138 PAD.n81 0.0033125
R713 PAD.n138 PAD.n83 0.0033125
R714 PAD.n130 PAD.n83 0.0033125
R715 PAD.n130 PAD.n89 0.0033125
R716 PAD.n126 PAD.n89 0.0033125
R717 PAD.n126 PAD.n91 0.0033125
R718 PAD.n118 PAD.n91 0.0033125
R719 PAD.n118 PAD.n97 0.0033125
R720 PAD.n114 PAD.n97 0.0033125
R721 PAD.n114 PAD.n99 0.0033125
R722 PAD.n106 PAD.n99 0.0033125
R723 PAD.n106 PAD.n103 0.0033125
R724 PAD.n197 PAD.n0 0.0033125
R725 PAD.n189 PAD.n0 0.0033125
R726 PAD.n189 PAD.n188 0.0033125
R727 PAD.n188 PAD.n187 0.0033125
R728 PAD.n187 PAD.n47 0.0033125
R729 PAD.n177 PAD.n47 0.0033125
R730 PAD.n177 PAD.n176 0.0033125
R731 PAD.n176 PAD.n175 0.0033125
R732 PAD.n175 PAD.n58 0.0033125
R733 PAD.n165 PAD.n58 0.0033125
R734 PAD.n165 PAD.n164 0.0033125
R735 PAD.n164 PAD.n163 0.0033125
R736 PAD.n163 PAD.n66 0.0033125
R737 PAD.n153 PAD.n66 0.0033125
R738 PAD.n153 PAD.n152 0.0033125
R739 PAD.n152 PAD.n151 0.0033125
R740 PAD.n151 PAD.n74 0.0033125
R741 PAD.n141 PAD.n74 0.0033125
R742 PAD.n141 PAD.n140 0.0033125
R743 PAD.n140 PAD.n139 0.0033125
R744 PAD.n139 PAD.n82 0.0033125
R745 PAD.n129 PAD.n82 0.0033125
R746 PAD.n129 PAD.n128 0.0033125
R747 PAD.n128 PAD.n127 0.0033125
R748 PAD.n127 PAD.n90 0.0033125
R749 PAD.n117 PAD.n90 0.0033125
R750 PAD.n117 PAD.n116 0.0033125
R751 PAD.n116 PAD.n115 0.0033125
R752 PAD.n115 PAD.n98 0.0033125
R753 PAD.n105 PAD.n98 0.0033125
R754 PAD.n195 PAD.n2 0.0033125
R755 PAD.n191 PAD.n2 0.0033125
R756 PAD.n191 PAD.n45 0.0033125
R757 PAD.n185 PAD.n45 0.0033125
R758 PAD.n185 PAD.n49 0.0033125
R759 PAD.n179 PAD.n53 0.0033125
R760 PAD.n173 PAD.n53 0.0033125
R761 PAD.n173 PAD.n60 0.0033125
R762 PAD.n167 PAD.n60 0.0033125
R763 PAD.n167 PAD.n64 0.0033125
R764 PAD.n161 PAD.n64 0.0033125
R765 PAD.n161 PAD.n68 0.0033125
R766 PAD.n155 PAD.n68 0.0033125
R767 PAD.n155 PAD.n72 0.0033125
R768 PAD.n149 PAD.n72 0.0033125
R769 PAD.n149 PAD.n76 0.0033125
R770 PAD.n143 PAD.n76 0.0033125
R771 PAD.n143 PAD.n80 0.0033125
R772 PAD.n137 PAD.n80 0.0033125
R773 PAD.n137 PAD.n84 0.0033125
R774 PAD.n131 PAD.n84 0.0033125
R775 PAD.n131 PAD.n88 0.0033125
R776 PAD.n125 PAD.n88 0.0033125
R777 PAD.n125 PAD.n92 0.0033125
R778 PAD.n119 PAD.n92 0.0033125
R779 PAD.n119 PAD.n96 0.0033125
R780 PAD.n113 PAD.n96 0.0033125
R781 PAD.n113 PAD.n100 0.0033125
R782 PAD.n107 PAD.n100 0.0033125
R783 PAD.n107 PAD.n102 0.0033125
R784 PAD.n192 PAD.n42 0.0033125
R785 PAD.n192 PAD.n44 0.0033125
R786 PAD.n184 PAD.n44 0.0033125
R787 PAD.n184 PAD.n50 0.0033125
R788 PAD.n180 PAD.n50 0.0033125
R789 PAD.n180 PAD.n52 0.0033125
R790 PAD.n172 PAD.n52 0.0033125
R791 PAD.n172 PAD.n61 0.0033125
R792 PAD.n168 PAD.n61 0.0033125
R793 PAD.n168 PAD.n63 0.0033125
R794 PAD.n160 PAD.n63 0.0033125
R795 PAD.n160 PAD.n69 0.0033125
R796 PAD.n156 PAD.n69 0.0033125
R797 PAD.n156 PAD.n71 0.0033125
R798 PAD.n148 PAD.n71 0.0033125
R799 PAD.n148 PAD.n77 0.0033125
R800 PAD.n144 PAD.n77 0.0033125
R801 PAD.n144 PAD.n79 0.0033125
R802 PAD.n136 PAD.n79 0.0033125
R803 PAD.n136 PAD.n85 0.0033125
R804 PAD.n132 PAD.n85 0.0033125
R805 PAD.n132 PAD.n87 0.0033125
R806 PAD.n124 PAD.n87 0.0033125
R807 PAD.n124 PAD.n93 0.0033125
R808 PAD.n120 PAD.n93 0.0033125
R809 PAD.n120 PAD.n95 0.0033125
R810 PAD.n112 PAD.n95 0.0033125
R811 PAD.n112 PAD.n101 0.0033125
R812 PAD.n108 PAD.n101 0.0033125
R813 PAD.n57 PAD.n48 0.00256719
R814 PAD.n55 PAD.n49 0.00256719
R815 PAD.n194 PAD.n42 0.00238623
R816 PAD.n109 PAD.n108 0.00238623
R817 PAD.n193 PAD.n43 0.00175
R818 PAD.n183 PAD.n43 0.00175
R819 PAD.n183 PAD.n182 0.00175
R820 PAD.n182 PAD.n181 0.00175
R821 PAD.n181 PAD.n51 0.00175
R822 PAD.n171 PAD.n51 0.00175
R823 PAD.n171 PAD.n170 0.00175
R824 PAD.n170 PAD.n169 0.00175
R825 PAD.n169 PAD.n62 0.00175
R826 PAD.n159 PAD.n62 0.00175
R827 PAD.n159 PAD.n158 0.00175
R828 PAD.n158 PAD.n157 0.00175
R829 PAD.n157 PAD.n70 0.00175
R830 PAD.n147 PAD.n70 0.00175
R831 PAD.n147 PAD.n146 0.00175
R832 PAD.n146 PAD.n145 0.00175
R833 PAD.n145 PAD.n78 0.00175
R834 PAD.n135 PAD.n78 0.00175
R835 PAD.n135 PAD.n134 0.00175
R836 PAD.n134 PAD.n133 0.00175
R837 PAD.n133 PAD.n86 0.00175
R838 PAD.n123 PAD.n86 0.00175
R839 PAD.n123 PAD.n122 0.00175
R840 PAD.n122 PAD.n121 0.00175
R841 PAD.n121 PAD.n94 0.00175
R842 PAD.n111 PAD.n94 0.00175
R843 PAD.n111 PAD.n110 0.00175
R844 PAD.n178 PAD.n57 0.00124531
R845 PAD.n198 PAD.n197 0.00124531
R846 PAD.n179 PAD.n55 0.00124531
R847 PAD.n104 PAD.n103 0.00102002
R848 GN.n0 GN.t2 44.2698
R849 GN.n40 GN.n39 38.8567
R850 GN.n40 GN.n38 38.2238
R851 GN.n0 GN.t3 32.5898
R852 GN.n1 GN.t4 32.5898
R853 GN.n2 GN.t5 32.5898
R854 GN.n3 GN.t6 32.5898
R855 GN.n4 GN.t7 32.5898
R856 GN.n5 GN.t8 32.5898
R857 GN.n6 GN.t9 32.5898
R858 GN.n7 GN.t10 32.5898
R859 GN.n8 GN.t11 32.5898
R860 GN.n9 GN.t12 32.5898
R861 GN.n10 GN.t13 32.5898
R862 GN.n11 GN.t14 32.5898
R863 GN.n12 GN.t15 32.5898
R864 GN.n13 GN.t16 32.5898
R865 GN.n14 GN.t17 32.5898
R866 GN.n15 GN.t18 32.5898
R867 GN.n16 GN.t19 32.5898
R868 GN.n17 GN.t20 32.5898
R869 GN.n18 GN.t21 32.5898
R870 GN.n19 GN.t22 32.5898
R871 GN.n20 GN.t23 32.5898
R872 GN.n21 GN.t24 32.5898
R873 GN.n22 GN.t25 32.5898
R874 GN.n23 GN.t26 32.5898
R875 GN.n24 GN.t27 32.5898
R876 GN.n25 GN.t28 32.5898
R877 GN.n26 GN.t29 32.5898
R878 GN.n27 GN.t30 32.5898
R879 GN.n28 GN.t31 32.5898
R880 GN.n29 GN.t32 32.5898
R881 GN.n30 GN.t33 32.5898
R882 GN.n31 GN.t34 32.5898
R883 GN.n32 GN.t35 32.5898
R884 GN.n33 GN.t36 32.5898
R885 GN.n34 GN.t37 32.5898
R886 GN.n35 GN.t38 32.5898
R887 GN.n36 GN.t39 32.5898
R888 GN.n37 GN.t40 32.5898
R889 GN.n38 GN.t41 32.5898
R890 GN.n38 GN.n37 11.6805
R891 GN.n37 GN.n36 11.6805
R892 GN.n36 GN.n35 11.6805
R893 GN.n35 GN.n34 11.6805
R894 GN.n34 GN.n33 11.6805
R895 GN.n33 GN.n32 11.6805
R896 GN.n32 GN.n31 11.6805
R897 GN.n31 GN.n30 11.6805
R898 GN.n30 GN.n29 11.6805
R899 GN.n29 GN.n28 11.6805
R900 GN.n28 GN.n27 11.6805
R901 GN.n27 GN.n26 11.6805
R902 GN.n26 GN.n25 11.6805
R903 GN.n25 GN.n24 11.6805
R904 GN.n24 GN.n23 11.6805
R905 GN.n23 GN.n22 11.6805
R906 GN.n22 GN.n21 11.6805
R907 GN.n21 GN.n20 11.6805
R908 GN.n20 GN.n19 11.6805
R909 GN.n19 GN.n18 11.6805
R910 GN.n18 GN.n17 11.6805
R911 GN.n17 GN.n16 11.6805
R912 GN.n16 GN.n15 11.6805
R913 GN.n15 GN.n14 11.6805
R914 GN.n14 GN.n13 11.6805
R915 GN.n13 GN.n12 11.6805
R916 GN.n12 GN.n11 11.6805
R917 GN.n11 GN.n10 11.6805
R918 GN.n10 GN.n9 11.6805
R919 GN.n9 GN.n8 11.6805
R920 GN.n8 GN.n7 11.6805
R921 GN.n7 GN.n6 11.6805
R922 GN.n6 GN.n5 11.6805
R923 GN.n5 GN.n4 11.6805
R924 GN.n4 GN.n3 11.6805
R925 GN.n3 GN.n2 11.6805
R926 GN.n2 GN.n1 11.6805
R927 GN.n1 GN.n0 11.6805
R928 GN.n39 GN.t0 5.15205
R929 GN.n39 GN.t1 2.69247
R930 GN GN.n40 0.0262143
R931 GP.n0 GP.t2 88.5912
R932 GP.n0 GP.t3 76.9112
R933 GP.n1 GP.t4 76.9112
R934 GP.n2 GP.t5 76.9112
R935 GP.n3 GP.t6 76.9112
R936 GP.n4 GP.t7 76.9112
R937 GP.n5 GP.t8 76.9112
R938 GP.n6 GP.t9 76.9112
R939 GP.n7 GP.t10 76.9112
R940 GP.n8 GP.t11 76.9112
R941 GP.n9 GP.t12 76.9112
R942 GP.n10 GP.t13 76.9112
R943 GP.n11 GP.t14 76.9112
R944 GP.n12 GP.t15 76.9112
R945 GP.n13 GP.t16 76.9112
R946 GP.n14 GP.t17 76.9112
R947 GP.n15 GP.t18 76.9112
R948 GP.n16 GP.t19 76.9112
R949 GP.n17 GP.t20 76.9112
R950 GP.n18 GP.t21 76.9112
R951 GP.n19 GP.t22 76.9112
R952 GP.n20 GP.t23 76.9112
R953 GP.n21 GP.t24 76.9112
R954 GP.n22 GP.t25 76.9112
R955 GP.n23 GP.t26 76.9112
R956 GP.n24 GP.t27 76.9112
R957 GP.n25 GP.t28 76.9112
R958 GP.n26 GP.t29 76.9112
R959 GP.n27 GP.t30 76.9112
R960 GP.n28 GP.t31 76.9112
R961 GP.n29 GP.t32 76.9112
R962 GP.n30 GP.t33 76.9112
R963 GP.n31 GP.t34 76.9112
R964 GP.n32 GP.t35 76.9112
R965 GP.n33 GP.t36 76.9112
R966 GP.n34 GP.t37 76.9112
R967 GP.n35 GP.t38 76.9112
R968 GP.n36 GP.t39 76.9112
R969 GP.n37 GP.t40 76.9112
R970 GP.n38 GP.t41 76.9112
R971 GP.n40 GP.n39 41.6287
R972 GP.n40 GP.n38 38.2238
R973 GP.n38 GP.n37 11.6805
R974 GP.n37 GP.n36 11.6805
R975 GP.n36 GP.n35 11.6805
R976 GP.n35 GP.n34 11.6805
R977 GP.n34 GP.n33 11.6805
R978 GP.n33 GP.n32 11.6805
R979 GP.n32 GP.n31 11.6805
R980 GP.n31 GP.n30 11.6805
R981 GP.n30 GP.n29 11.6805
R982 GP.n29 GP.n28 11.6805
R983 GP.n28 GP.n27 11.6805
R984 GP.n27 GP.n26 11.6805
R985 GP.n26 GP.n25 11.6805
R986 GP.n25 GP.n24 11.6805
R987 GP.n24 GP.n23 11.6805
R988 GP.n23 GP.n22 11.6805
R989 GP.n22 GP.n21 11.6805
R990 GP.n21 GP.n20 11.6805
R991 GP.n20 GP.n19 11.6805
R992 GP.n19 GP.n18 11.6805
R993 GP.n18 GP.n17 11.6805
R994 GP.n17 GP.n16 11.6805
R995 GP.n16 GP.n15 11.6805
R996 GP.n15 GP.n14 11.6805
R997 GP.n14 GP.n13 11.6805
R998 GP.n13 GP.n12 11.6805
R999 GP.n12 GP.n11 11.6805
R1000 GP.n11 GP.n10 11.6805
R1001 GP.n10 GP.n9 11.6805
R1002 GP.n9 GP.n8 11.6805
R1003 GP.n8 GP.n7 11.6805
R1004 GP.n7 GP.n6 11.6805
R1005 GP.n6 GP.n5 11.6805
R1006 GP.n5 GP.n4 11.6805
R1007 GP.n4 GP.n3 11.6805
R1008 GP.n3 GP.n2 11.6805
R1009 GP.n2 GP.n1 11.6805
R1010 GP.n1 GP.n0 11.6805
R1011 GP.n39 GP.t1 5.15205
R1012 GP.n39 GP.t0 2.69247
R1013 GP GP.n40 0.0262143
R1014 PU_OK.t1 PU_OK.t0 119.407
R1015 PU_OK PU_OK.t1 52.6952
R1016 OE_N.t1 OE_N.t0 96.4648
R1017 OE_N OE_N.t1 53.144
R1018 OUT.t3 OUT.t1 96.4648
R1019 OUT.t2 OUT.t0 96.4648
R1020 OUT.n0 OUT.t2 47.237
R1021 OUT.n0 OUT.t3 40.559
R1022 OUT OUT.n0 12.8255
R1023 VDDIO VDDIO.t100 526.747
R1024 VDDIO VDDIO.t98 521.779
R1025 VDDIO.n42 VDDIO.t82 395.611
R1026 VDDIO.n43 VDDIO.t85 395.503
R1027 VDDIO.n45 VDDIO.t104 395.503
R1028 VDDIO.n47 VDDIO.t108 395.503
R1029 VDDIO.n41 VDDIO.t89 395.503
R1030 VDDIO.n39 VDDIO.t93 395.503
R1031 VDDIO.n38 VDDIO.t91 395.503
R1032 VDDIO.n36 VDDIO.t106 395.503
R1033 VDDIO.n34 VDDIO.t87 395.503
R1034 VDDIO.n32 VDDIO.t80 395.503
R1035 VDDIO.n30 VDDIO.t84 395.503
R1036 VDDIO.n29 VDDIO.t94 395.503
R1037 VDDIO.n27 VDDIO.t96 395.503
R1038 VDDIO.n66 VDDIO.t102 232.214
R1039 VDDIO.n0 VDDIO.t0 192.674
R1040 VDDIO.t0 VDDIO.t2 136.519
R1041 VDDIO.t2 VDDIO.t8 136.519
R1042 VDDIO.t8 VDDIO.t4 136.519
R1043 VDDIO.t4 VDDIO.t10 136.519
R1044 VDDIO.t10 VDDIO.t6 136.519
R1045 VDDIO.t6 VDDIO.t12 136.519
R1046 VDDIO.t12 VDDIO.t14 136.519
R1047 VDDIO.t14 VDDIO.t16 136.519
R1048 VDDIO.t16 VDDIO.t22 136.519
R1049 VDDIO.t22 VDDIO.t24 136.519
R1050 VDDIO.t24 VDDIO.t18 136.519
R1051 VDDIO.t18 VDDIO.t20 136.519
R1052 VDDIO.t20 VDDIO.t26 136.519
R1053 VDDIO.t26 VDDIO.t28 136.519
R1054 VDDIO.t28 VDDIO.t30 136.519
R1055 VDDIO.t30 VDDIO.t40 136.519
R1056 VDDIO.t40 VDDIO.t38 136.519
R1057 VDDIO.t38 VDDIO.t42 136.519
R1058 VDDIO.t42 VDDIO.t48 136.519
R1059 VDDIO.t48 VDDIO.t46 136.519
R1060 VDDIO.t46 VDDIO.t44 136.519
R1061 VDDIO.t44 VDDIO.t34 136.519
R1062 VDDIO.t34 VDDIO.t50 136.519
R1063 VDDIO.t50 VDDIO.t52 136.519
R1064 VDDIO.t52 VDDIO.t54 136.519
R1065 VDDIO.t54 VDDIO.t56 136.519
R1066 VDDIO.t56 VDDIO.t60 136.519
R1067 VDDIO.t60 VDDIO.t58 136.519
R1068 VDDIO.t58 VDDIO.t36 136.519
R1069 VDDIO.t36 VDDIO.t62 136.519
R1070 VDDIO.t62 VDDIO.t64 136.519
R1071 VDDIO.t64 VDDIO.t66 136.519
R1072 VDDIO.t66 VDDIO.t72 136.519
R1073 VDDIO.t72 VDDIO.t70 136.519
R1074 VDDIO.t70 VDDIO.t68 136.519
R1075 VDDIO.t68 VDDIO.t32 136.519
R1076 VDDIO.t32 VDDIO.t74 136.519
R1077 VDDIO.t74 VDDIO.t76 136.519
R1078 VDDIO.t76 VDDIO.t78 136.519
R1079 VDDIO.n50 VDDIO.n49 14.0765
R1080 VDDIO.n64 VDDIO.n63 10.7074
R1081 VDDIO.n65 VDDIO.n64 8.4605
R1082 VDDIO.n20 VDDIO.t79 7.27651
R1083 VDDIO.n20 VDDIO.n19 6.55251
R1084 VDDIO.n21 VDDIO.n18 6.55251
R1085 VDDIO.n22 VDDIO.n17 6.55251
R1086 VDDIO.n23 VDDIO.n16 6.55251
R1087 VDDIO.n24 VDDIO.n15 6.55251
R1088 VDDIO.n25 VDDIO.n14 6.55251
R1089 VDDIO.n26 VDDIO.n13 6.55251
R1090 VDDIO.n51 VDDIO.n12 6.55251
R1091 VDDIO.n52 VDDIO.n11 6.55251
R1092 VDDIO.n53 VDDIO.n10 6.55251
R1093 VDDIO.n54 VDDIO.n9 6.55251
R1094 VDDIO.n55 VDDIO.n8 6.55251
R1095 VDDIO.n56 VDDIO.n7 6.55251
R1096 VDDIO.n57 VDDIO.n6 6.55251
R1097 VDDIO.n58 VDDIO.n5 6.55251
R1098 VDDIO.n59 VDDIO.n4 6.55251
R1099 VDDIO.n60 VDDIO.n3 6.55251
R1100 VDDIO.n61 VDDIO.n2 6.55251
R1101 VDDIO.n62 VDDIO.n1 6.55251
R1102 VDDIO.n63 VDDIO.n0 5.80076
R1103 VDDIO VDDIO.n66 5.58476
R1104 VDDIO.n64 VDDIO 4.9355
R1105 VDDIO.n65 VDDIO 4.9355
R1106 VDDIO.n27 VDDIO.t97 3.0835
R1107 VDDIO.n42 VDDIO.t83 2.9755
R1108 VDDIO.n44 VDDIO.t86 2.9755
R1109 VDDIO.n46 VDDIO.t105 2.9755
R1110 VDDIO.n48 VDDIO.t109 2.9755
R1111 VDDIO.n40 VDDIO.t90 2.9755
R1112 VDDIO.n37 VDDIO.t92 2.9755
R1113 VDDIO.n35 VDDIO.t107 2.9755
R1114 VDDIO.n33 VDDIO.t88 2.9755
R1115 VDDIO.n31 VDDIO.t81 2.9755
R1116 VDDIO.n28 VDDIO.t95 2.9755
R1117 VDDIO.n66 VDDIO.t103 1.21208
R1118 VDDIO.n0 VDDIO.t1 1.1095
R1119 VDDIO VDDIO.n65 1.0805
R1120 VDDIO.n39 VDDIO.n38 0.5855
R1121 VDDIO.n30 VDDIO.n29 0.5855
R1122 VDDIO.n43 VDDIO.n42 0.4925
R1123 VDDIO.n45 VDDIO.n44 0.4925
R1124 VDDIO.n37 VDDIO.n36 0.4925
R1125 VDDIO.n35 VDDIO.n34 0.4925
R1126 VDDIO.n33 VDDIO.n32 0.4925
R1127 VDDIO.n28 VDDIO.n27 0.4925
R1128 VDDIO.n49 VDDIO.n41 0.4325
R1129 VDDIO.n19 VDDIO.t75 0.3645
R1130 VDDIO.n19 VDDIO.t77 0.3645
R1131 VDDIO.n18 VDDIO.t69 0.3645
R1132 VDDIO.n18 VDDIO.t33 0.3645
R1133 VDDIO.n17 VDDIO.t73 0.3645
R1134 VDDIO.n17 VDDIO.t71 0.3645
R1135 VDDIO.n16 VDDIO.t65 0.3645
R1136 VDDIO.n16 VDDIO.t67 0.3645
R1137 VDDIO.n15 VDDIO.t37 0.3645
R1138 VDDIO.n15 VDDIO.t63 0.3645
R1139 VDDIO.n14 VDDIO.t61 0.3645
R1140 VDDIO.n14 VDDIO.t59 0.3645
R1141 VDDIO.n13 VDDIO.t55 0.3645
R1142 VDDIO.n13 VDDIO.t57 0.3645
R1143 VDDIO.n12 VDDIO.t51 0.3645
R1144 VDDIO.n12 VDDIO.t53 0.3645
R1145 VDDIO.n11 VDDIO.t45 0.3645
R1146 VDDIO.n11 VDDIO.t35 0.3645
R1147 VDDIO.n10 VDDIO.t49 0.3645
R1148 VDDIO.n10 VDDIO.t47 0.3645
R1149 VDDIO.n9 VDDIO.t39 0.3645
R1150 VDDIO.n9 VDDIO.t43 0.3645
R1151 VDDIO.n8 VDDIO.t31 0.3645
R1152 VDDIO.n8 VDDIO.t41 0.3645
R1153 VDDIO.n7 VDDIO.t27 0.3645
R1154 VDDIO.n7 VDDIO.t29 0.3645
R1155 VDDIO.n6 VDDIO.t19 0.3645
R1156 VDDIO.n6 VDDIO.t21 0.3645
R1157 VDDIO.n5 VDDIO.t23 0.3645
R1158 VDDIO.n5 VDDIO.t25 0.3645
R1159 VDDIO.n4 VDDIO.t15 0.3645
R1160 VDDIO.n4 VDDIO.t17 0.3645
R1161 VDDIO.n3 VDDIO.t7 0.3645
R1162 VDDIO.n3 VDDIO.t13 0.3645
R1163 VDDIO.n2 VDDIO.t5 0.3645
R1164 VDDIO.n2 VDDIO.t11 0.3645
R1165 VDDIO.n1 VDDIO.t3 0.3645
R1166 VDDIO.n1 VDDIO.t9 0.3645
R1167 VDDIO.n62 VDDIO.n61 0.3605
R1168 VDDIO.n61 VDDIO.n60 0.3605
R1169 VDDIO.n60 VDDIO.n59 0.3605
R1170 VDDIO.n59 VDDIO.n58 0.3605
R1171 VDDIO.n58 VDDIO.n57 0.3605
R1172 VDDIO.n57 VDDIO.n56 0.3605
R1173 VDDIO.n56 VDDIO.n55 0.3605
R1174 VDDIO.n55 VDDIO.n54 0.3605
R1175 VDDIO.n54 VDDIO.n53 0.3605
R1176 VDDIO.n53 VDDIO.n52 0.3605
R1177 VDDIO.n52 VDDIO.n51 0.3605
R1178 VDDIO.n26 VDDIO.n25 0.3605
R1179 VDDIO.n25 VDDIO.n24 0.3605
R1180 VDDIO.n24 VDDIO.n23 0.3605
R1181 VDDIO.n23 VDDIO.n22 0.3605
R1182 VDDIO.n22 VDDIO.n21 0.3605
R1183 VDDIO.n21 VDDIO.n20 0.3605
R1184 VDDIO.n47 VDDIO.n46 0.3575
R1185 VDDIO.n40 VDDIO.n39 0.3575
R1186 VDDIO.n31 VDDIO.n30 0.3575
R1187 VDDIO VDDIO.n62 0.345535
R1188 VDDIO.n50 VDDIO.n26 0.221
R1189 VDDIO.n51 VDDIO.n50 0.14
R1190 VDDIO.n44 VDDIO.n43 0.1085
R1191 VDDIO.n46 VDDIO.n45 0.1085
R1192 VDDIO.n48 VDDIO.n47 0.1085
R1193 VDDIO.n41 VDDIO.n40 0.1085
R1194 VDDIO.n38 VDDIO.n37 0.1085
R1195 VDDIO.n36 VDDIO.n35 0.1085
R1196 VDDIO.n34 VDDIO.n33 0.1085
R1197 VDDIO.n32 VDDIO.n31 0.1085
R1198 VDDIO.n29 VDDIO.n28 0.1085
R1199 VDDIO.n49 VDDIO.n48 0.0455
R1200 VDDIO.n63 VDDIO 0.00259302
R1201 a_n7856_9000.n20 a_n7856_9000.t80 15.6427
R1202 a_n7856_9000.n39 a_n7856_9000.n0 6.66725
R1203 a_n7856_9000.n38 a_n7856_9000.n1 6.66725
R1204 a_n7856_9000.n37 a_n7856_9000.n2 6.66725
R1205 a_n7856_9000.n36 a_n7856_9000.n3 6.66725
R1206 a_n7856_9000.n35 a_n7856_9000.n4 6.66725
R1207 a_n7856_9000.n34 a_n7856_9000.n5 6.66725
R1208 a_n7856_9000.n33 a_n7856_9000.n6 6.66725
R1209 a_n7856_9000.n32 a_n7856_9000.n7 6.66725
R1210 a_n7856_9000.n31 a_n7856_9000.n8 6.66725
R1211 a_n7856_9000.n30 a_n7856_9000.n9 6.66725
R1212 a_n7856_9000.n29 a_n7856_9000.n10 6.66725
R1213 a_n7856_9000.n28 a_n7856_9000.n11 6.66725
R1214 a_n7856_9000.n27 a_n7856_9000.n12 6.66725
R1215 a_n7856_9000.n26 a_n7856_9000.n13 6.66725
R1216 a_n7856_9000.n25 a_n7856_9000.n14 6.66725
R1217 a_n7856_9000.n24 a_n7856_9000.n15 6.66725
R1218 a_n7856_9000.n23 a_n7856_9000.n16 6.66725
R1219 a_n7856_9000.n22 a_n7856_9000.n17 6.66725
R1220 a_n7856_9000.n21 a_n7856_9000.n18 6.66725
R1221 a_n7856_9000.n20 a_n7856_9000.n19 6.66725
R1222 a_n7856_9000.n59 a_n7856_9000.n58 6.34065
R1223 a_n7856_9000.n78 a_n7856_9000.n77 6.00576
R1224 a_n7856_9000.n59 a_n7856_9000.n57 6.00576
R1225 a_n7856_9000.n60 a_n7856_9000.n56 6.00576
R1226 a_n7856_9000.n61 a_n7856_9000.n55 6.00576
R1227 a_n7856_9000.n62 a_n7856_9000.n54 6.00576
R1228 a_n7856_9000.n63 a_n7856_9000.n53 6.00576
R1229 a_n7856_9000.n64 a_n7856_9000.n52 6.00576
R1230 a_n7856_9000.n65 a_n7856_9000.n51 6.00576
R1231 a_n7856_9000.n66 a_n7856_9000.n50 6.00576
R1232 a_n7856_9000.n67 a_n7856_9000.n49 6.00576
R1233 a_n7856_9000.n68 a_n7856_9000.n48 6.00576
R1234 a_n7856_9000.n69 a_n7856_9000.n47 6.00576
R1235 a_n7856_9000.n70 a_n7856_9000.n46 6.00576
R1236 a_n7856_9000.n71 a_n7856_9000.n45 6.00576
R1237 a_n7856_9000.n72 a_n7856_9000.n44 6.00576
R1238 a_n7856_9000.n73 a_n7856_9000.n43 6.00576
R1239 a_n7856_9000.n74 a_n7856_9000.n42 6.00576
R1240 a_n7856_9000.n75 a_n7856_9000.n41 6.00576
R1241 a_n7856_9000.n76 a_n7856_9000.n40 6.00576
R1242 a_n7856_9000.n77 a_n7856_9000.n39 2.08681
R1243 a_n7856_9000.n0 a_n7856_9000.t40 0.8195
R1244 a_n7856_9000.n0 a_n7856_9000.t41 0.8195
R1245 a_n7856_9000.n1 a_n7856_9000.t42 0.8195
R1246 a_n7856_9000.n1 a_n7856_9000.t43 0.8195
R1247 a_n7856_9000.n2 a_n7856_9000.t44 0.8195
R1248 a_n7856_9000.n2 a_n7856_9000.t45 0.8195
R1249 a_n7856_9000.n3 a_n7856_9000.t46 0.8195
R1250 a_n7856_9000.n3 a_n7856_9000.t47 0.8195
R1251 a_n7856_9000.n4 a_n7856_9000.t48 0.8195
R1252 a_n7856_9000.n4 a_n7856_9000.t49 0.8195
R1253 a_n7856_9000.n5 a_n7856_9000.t50 0.8195
R1254 a_n7856_9000.n5 a_n7856_9000.t51 0.8195
R1255 a_n7856_9000.n6 a_n7856_9000.t52 0.8195
R1256 a_n7856_9000.n6 a_n7856_9000.t53 0.8195
R1257 a_n7856_9000.n7 a_n7856_9000.t54 0.8195
R1258 a_n7856_9000.n7 a_n7856_9000.t55 0.8195
R1259 a_n7856_9000.n8 a_n7856_9000.t56 0.8195
R1260 a_n7856_9000.n8 a_n7856_9000.t57 0.8195
R1261 a_n7856_9000.n9 a_n7856_9000.t58 0.8195
R1262 a_n7856_9000.n9 a_n7856_9000.t59 0.8195
R1263 a_n7856_9000.n10 a_n7856_9000.t60 0.8195
R1264 a_n7856_9000.n10 a_n7856_9000.t61 0.8195
R1265 a_n7856_9000.n11 a_n7856_9000.t62 0.8195
R1266 a_n7856_9000.n11 a_n7856_9000.t63 0.8195
R1267 a_n7856_9000.n12 a_n7856_9000.t64 0.8195
R1268 a_n7856_9000.n12 a_n7856_9000.t65 0.8195
R1269 a_n7856_9000.n13 a_n7856_9000.t66 0.8195
R1270 a_n7856_9000.n13 a_n7856_9000.t67 0.8195
R1271 a_n7856_9000.n14 a_n7856_9000.t68 0.8195
R1272 a_n7856_9000.n14 a_n7856_9000.t69 0.8195
R1273 a_n7856_9000.n15 a_n7856_9000.t70 0.8195
R1274 a_n7856_9000.n15 a_n7856_9000.t71 0.8195
R1275 a_n7856_9000.n16 a_n7856_9000.t72 0.8195
R1276 a_n7856_9000.n16 a_n7856_9000.t73 0.8195
R1277 a_n7856_9000.n17 a_n7856_9000.t74 0.8195
R1278 a_n7856_9000.n17 a_n7856_9000.t75 0.8195
R1279 a_n7856_9000.n18 a_n7856_9000.t76 0.8195
R1280 a_n7856_9000.n18 a_n7856_9000.t77 0.8195
R1281 a_n7856_9000.n19 a_n7856_9000.t78 0.8195
R1282 a_n7856_9000.n19 a_n7856_9000.t79 0.8195
R1283 a_n7856_9000.n78 a_n7856_9000.t38 0.3645
R1284 a_n7856_9000.t39 a_n7856_9000.n78 0.3645
R1285 a_n7856_9000.n58 a_n7856_9000.t0 0.3645
R1286 a_n7856_9000.n58 a_n7856_9000.t1 0.3645
R1287 a_n7856_9000.n57 a_n7856_9000.t2 0.3645
R1288 a_n7856_9000.n57 a_n7856_9000.t3 0.3645
R1289 a_n7856_9000.n56 a_n7856_9000.t4 0.3645
R1290 a_n7856_9000.n56 a_n7856_9000.t5 0.3645
R1291 a_n7856_9000.n55 a_n7856_9000.t6 0.3645
R1292 a_n7856_9000.n55 a_n7856_9000.t7 0.3645
R1293 a_n7856_9000.n54 a_n7856_9000.t8 0.3645
R1294 a_n7856_9000.n54 a_n7856_9000.t9 0.3645
R1295 a_n7856_9000.n53 a_n7856_9000.t10 0.3645
R1296 a_n7856_9000.n53 a_n7856_9000.t11 0.3645
R1297 a_n7856_9000.n52 a_n7856_9000.t12 0.3645
R1298 a_n7856_9000.n52 a_n7856_9000.t13 0.3645
R1299 a_n7856_9000.n51 a_n7856_9000.t14 0.3645
R1300 a_n7856_9000.n51 a_n7856_9000.t15 0.3645
R1301 a_n7856_9000.n50 a_n7856_9000.t16 0.3645
R1302 a_n7856_9000.n50 a_n7856_9000.t17 0.3645
R1303 a_n7856_9000.n49 a_n7856_9000.t18 0.3645
R1304 a_n7856_9000.n49 a_n7856_9000.t19 0.3645
R1305 a_n7856_9000.n48 a_n7856_9000.t20 0.3645
R1306 a_n7856_9000.n48 a_n7856_9000.t21 0.3645
R1307 a_n7856_9000.n47 a_n7856_9000.t22 0.3645
R1308 a_n7856_9000.n47 a_n7856_9000.t23 0.3645
R1309 a_n7856_9000.n46 a_n7856_9000.t24 0.3645
R1310 a_n7856_9000.n46 a_n7856_9000.t25 0.3645
R1311 a_n7856_9000.n45 a_n7856_9000.t26 0.3645
R1312 a_n7856_9000.n45 a_n7856_9000.t27 0.3645
R1313 a_n7856_9000.n44 a_n7856_9000.t28 0.3645
R1314 a_n7856_9000.n44 a_n7856_9000.t29 0.3645
R1315 a_n7856_9000.n43 a_n7856_9000.t30 0.3645
R1316 a_n7856_9000.n43 a_n7856_9000.t31 0.3645
R1317 a_n7856_9000.n42 a_n7856_9000.t32 0.3645
R1318 a_n7856_9000.n42 a_n7856_9000.t33 0.3645
R1319 a_n7856_9000.n41 a_n7856_9000.t34 0.3645
R1320 a_n7856_9000.n41 a_n7856_9000.t35 0.3645
R1321 a_n7856_9000.n40 a_n7856_9000.t36 0.3645
R1322 a_n7856_9000.n40 a_n7856_9000.t37 0.3645
R1323 a_n7856_9000.n60 a_n7856_9000.n59 0.335384
R1324 a_n7856_9000.n61 a_n7856_9000.n60 0.335384
R1325 a_n7856_9000.n62 a_n7856_9000.n61 0.335384
R1326 a_n7856_9000.n63 a_n7856_9000.n62 0.335384
R1327 a_n7856_9000.n64 a_n7856_9000.n63 0.335384
R1328 a_n7856_9000.n65 a_n7856_9000.n64 0.335384
R1329 a_n7856_9000.n66 a_n7856_9000.n65 0.335384
R1330 a_n7856_9000.n67 a_n7856_9000.n66 0.335384
R1331 a_n7856_9000.n68 a_n7856_9000.n67 0.335384
R1332 a_n7856_9000.n69 a_n7856_9000.n68 0.335384
R1333 a_n7856_9000.n70 a_n7856_9000.n69 0.335384
R1334 a_n7856_9000.n71 a_n7856_9000.n70 0.335384
R1335 a_n7856_9000.n72 a_n7856_9000.n71 0.335384
R1336 a_n7856_9000.n73 a_n7856_9000.n72 0.335384
R1337 a_n7856_9000.n74 a_n7856_9000.n73 0.335384
R1338 a_n7856_9000.n75 a_n7856_9000.n74 0.335384
R1339 a_n7856_9000.n76 a_n7856_9000.n75 0.335384
R1340 a_n7856_9000.n77 a_n7856_9000.n76 0.335384
R1341 a_n7856_9000.n39 a_n7856_9000.n38 0.253132
R1342 a_n7856_9000.n38 a_n7856_9000.n37 0.253132
R1343 a_n7856_9000.n37 a_n7856_9000.n36 0.253132
R1344 a_n7856_9000.n36 a_n7856_9000.n35 0.253132
R1345 a_n7856_9000.n35 a_n7856_9000.n34 0.253132
R1346 a_n7856_9000.n34 a_n7856_9000.n33 0.253132
R1347 a_n7856_9000.n33 a_n7856_9000.n32 0.253132
R1348 a_n7856_9000.n32 a_n7856_9000.n31 0.253132
R1349 a_n7856_9000.n31 a_n7856_9000.n30 0.253132
R1350 a_n7856_9000.n30 a_n7856_9000.n29 0.253132
R1351 a_n7856_9000.n29 a_n7856_9000.n28 0.253132
R1352 a_n7856_9000.n28 a_n7856_9000.n27 0.253132
R1353 a_n7856_9000.n27 a_n7856_9000.n26 0.253132
R1354 a_n7856_9000.n26 a_n7856_9000.n25 0.253132
R1355 a_n7856_9000.n25 a_n7856_9000.n24 0.253132
R1356 a_n7856_9000.n24 a_n7856_9000.n23 0.253132
R1357 a_n7856_9000.n23 a_n7856_9000.n22 0.253132
R1358 a_n7856_9000.n22 a_n7856_9000.n21 0.253132
R1359 a_n7856_9000.n21 a_n7856_9000.n20 0.253132
R1360 a_628_11080.t0 a_628_11080.t1 6.08195
R1361 a_n3172_11080.t0 a_n3172_11080.t1 6.08195
R1362 a_n4804_11920.t0 a_n4804_11920.t1 10.5985
R1363 a_2028_11080.t3 a_2028_11080.t2 96.4648
R1364 a_2028_11080.n0 a_2028_11080.t3 56.8672
R1365 a_2028_11080.n0 a_2028_11080.t1 5.15205
R1366 a_2028_11080.t0 a_2028_11080.n0 2.69247
R1367 a_628_11920.t4 a_628_11920.t3 96.4648
R1368 a_628_11920.n0 a_628_11920.t4 51.971
R1369 a_628_11920.n0 a_628_11920.t2 9.50876
R1370 a_628_11920.n1 a_628_11920.n0 5.063
R1371 a_628_11920.n1 a_628_11920.t1 4.87376
R1372 a_628_11920.t0 a_628_11920.n1 2.97195
R1373 a_n972_11080.t3 a_n972_11080.t2 96.4648
R1374 a_n972_11080.n0 a_n972_11080.t3 55.4272
R1375 a_n972_11080.n0 a_n972_11080.t0 5.15205
R1376 a_n972_11080.t1 a_n972_11080.n0 2.69247
R1377 a_n1772_11080.t3 a_n1772_11080.t2 96.4648
R1378 a_n1772_11080.n0 a_n1772_11080.t3 54.9472
R1379 a_n1772_11080.n0 a_n1772_11080.t1 5.15205
R1380 a_n1772_11080.t0 a_n1772_11080.n0 2.69247
R1381 a_n3172_11920.t4 a_n3172_11920.t3 96.4648
R1382 a_n3172_11920.n0 a_n3172_11920.t4 50.051
R1383 a_n3172_11920.n0 a_n3172_11920.t2 9.50876
R1384 a_n3172_11920.n1 a_n3172_11920.n0 5.063
R1385 a_n3172_11920.n1 a_n3172_11920.t1 4.87376
R1386 a_n3172_11920.t0 a_n3172_11920.n1 2.97195
R1387 a_n6172_11080.t3 a_n6172_11080.t2 96.4648
R1388 a_n6172_11080.n0 a_n6172_11080.t3 55.5652
R1389 a_n6172_11080.n0 a_n6172_11080.t0 5.15205
R1390 a_n6172_11080.t1 a_n6172_11080.n0 2.69247
R1391 a_n4948_11920.t6 a_n4948_11920.t4 96.4648
R1392 a_n4948_11920.t5 a_n4948_11920.t3 96.4648
R1393 a_n4948_11920.n0 a_n4948_11920.t5 45.179
R1394 a_n4948_11920.n0 a_n4948_11920.t6 41.759
R1395 a_n4948_11920.n2 a_n4948_11920.t0 10.1312
R1396 a_n4948_11920.n1 a_n4948_11920.n0 7.8772
R1397 a_n4948_11920.n1 a_n4948_11920.t2 7.09797
R1398 a_n4948_11920.t1 a_n4948_11920.n2 7.09797
R1399 a_n4948_11920.n2 a_n4948_11920.n1 0.607022
R1400 a_n5372_11080.t3 a_n5372_11080.t2 119.407
R1401 a_n5372_11080.n0 a_n5372_11080.t3 53.8564
R1402 a_n5372_11080.n0 a_n5372_11080.t0 5.15205
R1403 a_n5372_11080.t1 a_n5372_11080.n0 2.69247
C0 GP VDDIO 7.34963f
C1 PAD VSSIO 0.19476p
C2 GN VSSIO 12.22038f
C3 GP VSSIO 8.30949f
C4 PU_OK VSSIO 4.38433f
C5 OE_N VSSIO 4.52714f
C6 OUT VSSIO 5.80163f
C7 VDDIO VSSIO 85.85404f
C8 VDDIO.t98 VSSIO 2.96988f
C9 OUT.n0 VSSIO 2.73011f
C10 GP.n39 VSSIO 2.06022f
.ends
