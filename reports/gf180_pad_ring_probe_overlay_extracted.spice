* Extracted by KLayout with GF180MCU LVS runset on : 28/11/2026 06:09

* cell gf180_pad_ring
.SUBCKT gf180_pad_ring
* cell instance $1 r0 *1 140,90
X$1 VSSIO VSSIO \$I349 VSSIO VSSIO VSSIO \$I225 VSSIO VSSIO VDDIO VDDIO VDDIO
+ VDDIO gf180_pad_tile
* cell instance $2 r270 *1 90,1421.66
X$2 \$I217 VSSIO pad_cmd[6] \$I341 \$I310 \$I279 \$I248 VSSIO VSSIO VDDIO VDDIO
+ VDDIO VDDIO gf180_pad_tile
* cell instance $3 r270 *1 90,1231.66
X$3 \$I216 VSSIO pad_cmd[5] \$I340 \$I309 \$I278 \$I247 VSSIO VSSIO VDDIO VDDIO
+ VDDIO VDDIO gf180_pad_tile
* cell instance $4 r270 *1 90,1041.66
X$4 \$I215 VSSIO pad_cmd[4] \$I339 \$I308 \$I277 \$I246 VSSIO VSSIO VDDIO VDDIO
+ VDDIO VDDIO gf180_pad_tile
* cell instance $5 r270 *1 90,851.66
X$5 \$I214 VSSIO pad_cmd[3] \$I338 \$I307 \$I276 \$I245 VSSIO VSSIO VDDIO VDDIO
+ VDDIO VDDIO gf180_pad_tile
* cell instance $6 r270 *1 90,661.66
X$6 \$I213 VSSIO pad_cmd[2] \$I337 \$I306 \$I275 \$I244 VSSIO VSSIO VDDIO VDDIO
+ VDDIO VDDIO gf180_pad_tile
* cell instance $7 r270 *1 90,471.66
X$7 \$I212 VSSIO pad_cmd[1] \$I336 \$I305 \$I274 \$I243 VSSIO VSSIO VDDIO VDDIO
+ VDDIO VDDIO gf180_pad_tile
* cell instance $8 r270 *1 90,281.66
X$8 \$I211 VSSIO pad_cmd[0] \$I335 \$I304 \$I273 \$I242 VSSIO VSSIO VDDIO VDDIO
+ VDDIO VDDIO gf180_pad_tile
* cell instance $9 r180 *1 140,1710
X$9 VSSIO VSSIO pad_cmd[7] \$I334 \$I303 \$I272 VSSIO VSSIO VSSIO VDDIO VDDIO
+ VDDIO VDDIO gf180_pad_tile
* cell instance $10 r180 *1 330,1710
X$10 \$I209 VSSIO pad_cmd[8] \$I333 \$I302 \$I271 \$I240 VSSIO VSSIO VDDIO
+ VDDIO VDDIO VDDIO gf180_pad_tile
* cell instance $11 r180 *1 520,1710
X$11 \$I208 VSSIO pad_cmd[9] \$I332 \$I301 \$I270 \$I239 VSSIO VSSIO VDDIO
+ VDDIO VDDIO VDDIO gf180_pad_tile
* cell instance $12 r180 *1 710,1710
X$12 \$I207 VSSIO pad_cmd[10] \$I331 \$I300 \$I269 \$I238 VSSIO VSSIO VDDIO
+ VDDIO VDDIO VDDIO gf180_pad_tile
* cell instance $13 r180 *1 900,1710
X$13 \$I206 VSSIO pad_cmd[17] \$I330 \$I299 \$I268 \$I237 VSSIO VSSIO VDDIO
+ VDDIO VDDIO VDDIO gf180_pad_tile
* cell instance $14 r180 *1 1090,1710
X$14 \$I205 VSSIO pad_cmd[18] \$I329 \$I298 \$I267 \$I236 VSSIO VSSIO VDDIO
+ VDDIO VDDIO VDDIO gf180_pad_tile
* cell instance $15 r180 *1 1280,1710
X$15 \$I204 VSSIO pad_cmd[19] \$I328 \$I297 \$I266 \$I235 VSSIO VSSIO VDDIO
+ VDDIO VDDIO VDDIO gf180_pad_tile
* cell instance $16 r180 *1 1660,1710
X$16 VSSIO VSSIO pad_dq[7] VSSIO VSSIO VSSIO \$I234 VSSIO VSSIO VDDIO VDDIO
+ VDDIO VDDIO gf180_pad_tile
* cell instance $17 r180 *1 1470,1710
X$17 \$I202 VSSIO pad_cmd[20] \$I327 \$I296 \$I265 \$I233 VSSIO VSSIO VDDIO
+ VDDIO VDDIO VDDIO gf180_pad_tile
* cell instance $18 r90 *1 1710,281.66
X$18 \$I201 VSSIO pad_dq[0] \$I326 \$I295 \$I264 \$I232 VSSIO VSSIO VDDIO VDDIO
+ VDDIO VDDIO gf180_pad_tile
* cell instance $19 r90 *1 1710,471.66
X$19 \$I200 VSSIO pad_dq[1] \$I325 \$I294 \$I263 \$I231 VSSIO VSSIO VDDIO VDDIO
+ VDDIO VDDIO gf180_pad_tile
* cell instance $20 r90 *1 1710,661.66
X$20 \$I199 VSSIO pad_dq[2] \$I324 \$I293 \$I262 \$I230 VSSIO VSSIO VDDIO VDDIO
+ VDDIO VDDIO gf180_pad_tile
* cell instance $21 r90 *1 1710,851.66
X$21 \$I198 VSSIO pad_dq[3] \$I323 \$I292 \$I261 \$I229 VSSIO VSSIO VDDIO VDDIO
+ VDDIO VDDIO gf180_pad_tile
* cell instance $22 r90 *1 1710,1041.66
X$22 \$I197 VSSIO pad_dq[4] \$I322 \$I291 \$I260 \$I228 VSSIO VSSIO VDDIO VDDIO
+ VDDIO VDDIO gf180_pad_tile
* cell instance $23 r90 *1 1710,1231.66
X$23 \$I196 VSSIO pad_dq[5] \$I321 \$I290 \$I259 \$I227 VSSIO VSSIO VDDIO VDDIO
+ VDDIO VDDIO gf180_pad_tile
* cell instance $24 r90 *1 1710,1421.66
X$24 \$I195 VSSIO pad_dq[6] \$I320 \$I289 \$I258 \$I226 VSSIO VSSIO VDDIO VDDIO
+ VDDIO VDDIO gf180_pad_tile
* cell instance $25 r0 *1 1660,90
X$25 VSSIO VSSIO \$I348 \$I318 \$I287 \$I256 VSSIO VSSIO VSSIO VDDIO VDDIO
+ VDDIO VDDIO gf180_pad_tile
* cell instance $26 r0 *1 1470,90
X$26 \$I193 VSSIO pad_cmd[16] \$I317 \$I286 \$I255 \$I224 VSSIO VSSIO VDDIO
+ VDDIO VDDIO VDDIO gf180_pad_tile
* cell instance $27 r0 *1 1280,90
X$27 \$I192 VSSIO pad_cmd[15] \$I316 \$I285 \$I254 \$I223 VSSIO VSSIO VDDIO
+ VDDIO VDDIO VDDIO gf180_pad_tile
* cell instance $28 r0 *1 1090,90
X$28 \$I191 VSSIO pad_cmd[14] \$I315 \$I284 \$I253 \$I222 VSSIO VSSIO VDDIO
+ VDDIO VDDIO VDDIO gf180_pad_tile
* cell instance $29 r0 *1 900,90
X$29 \$I190 VSSIO pad_ck \$I314 \$I283 \$I252 \$I221 VSSIO VSSIO VDDIO VDDIO
+ VDDIO VDDIO gf180_pad_tile
* cell instance $30 r0 *1 710,90
X$30 \$I189 VSSIO pad_cmd[13] \$I313 \$I282 \$I251 \$I220 VSSIO VSSIO VDDIO
+ VDDIO VDDIO VDDIO gf180_pad_tile
* cell instance $31 r0 *1 520,90
X$31 \$I188 VSSIO pad_cmd[12] \$I312 \$I281 \$I250 \$I219 VSSIO VSSIO VDDIO
+ VDDIO VDDIO VDDIO gf180_pad_tile
* cell instance $32 r0 *1 330,90
X$32 \$I187 VSSIO pad_cmd[11] \$I311 \$I280 \$I249 \$I218 VSSIO VSSIO VDDIO
+ VDDIO VDDIO VDDIO gf180_pad_tile
.ENDS gf180_pad_ring

* cell gf180_pad_tile
* pin
* pin VSSIO
* pin
* pin
* pin
* pin
* pin
* pin
* pin
* pin
* pin
* pin
* pin
.SUBCKT gf180_pad_tile \$2 VSSIO \$I11 \$I10 \$I9 \$I8 \$I7 \$I6 \$I5 \$I4 \$I3
+ \$I2 \$I1
* cell instance $1 r0 *1 0,0
X$1 \$I1 \$I2 \$I4 \$I3 \$I11 \$I5 \$I6 \$I7 \$I8 \$I9 \$I10 VSSIO
+ gf180_pad_core
.ENDS gf180_pad_tile

* cell gf180_pad_core
* pin VDDIO
* pin
* pin
* pin
* pin PAD
* pin
* pin
* pin
* pin
* pin
* pin
* pin VSSIO
.SUBCKT gf180_pad_core VDDIO \$16 \$20 \$21 PAD \$438 \$439 \$616 \$625 \$629
+ \$630 VSSIO
* cell instance $1 r0 *1 -10,-62
X$1 VDDIO IN VDDIO PAD pmos$1
* cell instance $2 r0 *1 -10,-50
X$2 VSSIO IN PAD VSSIO nfet$1
* cell instance $3 r0 *1 -55,-38
X$3 VDDIO VSSIO diode_pn$1
* cell instance $4 r0 *1 -55,10
X$4 VDDIO PAD diode_pn
* cell instance $5 r0 *1 -40,45
X$5 VDDIO VDDIO \$440 VDDIO \$440 VDDIO \$440 VDDIO \$440 VDDIO \$440 VDDIO
+ \$440 VDDIO \$440 VDDIO \$440 VDDIO \$440 VDDIO \$440 VDDIO \$440 VDDIO \$440
+ VDDIO \$440 VDDIO \$440 VDDIO \$440 VDDIO \$440 VDDIO \$440 VDDIO \$440 VDDIO
+ \$440 VDDIO \$440 VDDIO GP GP GP GP GP GP GP GP GP GP GP GP GP GP GP GP GP GP
+ GP GP GP GP GP GP GP GP GP GP GP GP GP GP GP GP GP GP GP GP GP GP pmos
* cell instance $6 r0 *1 -31.58,55.4
X$6 VDDIO \$600 VDDIO OUT pmos$2
* cell instance $7 r0 *1 -27.58,55.4
X$7 VDDIO \$601 VDDIO OE_N pmos$3
* cell instance $8 r0 *1 -23.58,55.4
X$8 VDDIO \$571 VDDIO PU_OK pmos$4
* cell instance $9 r0 *1 -16.58,55.4
X$9 VDDIO \$603 VDDIO \$571 pmos$6
* cell instance $10 r0 *1 -13.48,55.4
X$10 \$603 \$604 VDDIO \$600 pmos$7
* cell instance $11 r0 *1 -20.48,55.4
X$11 VDDIO \$571 VDDIO \$601 pmos$5
* cell instance $12 r0 *1 -9.58,55.4
X$12 VDDIO \$605 VDDIO \$604 pmos$8
* cell instance $13 r0 *1 -5.58,55.4
X$13 VDDIO \$606 VDDIO \$605 pmos$9
* cell instance $14 r0 *1 -1.58,55.4
X$14 VDDIO GP VDDIO \$606 pmos$10
* cell instance $15 r0 *1 2.42,55.4
X$15 VDDIO \$607 VDDIO \$571 pmos$11
* cell instance $16 r0 *1 5.52,55.4
X$16 \$607 \$608 VDDIO OUT pmos$12
* cell instance $17 r0 *1 9.42,55.4
X$17 VDDIO \$609 VDDIO \$608 pmos$13
* cell instance $18 r0 *1 13.42,55.4
X$18 VDDIO GN VDDIO \$609 pmos$14
* cell instance $19 r0 *1 -55,-24
X$19 PAD VSSIO diode_np$1
* cell instance $20 r0 *1 -55,-10
X$20 PAD VSSIO diode_np
* cell instance $21 r0 *1 36,-11
X$21 \$440 PAD VSSIO ppolyf_u_resistor
* cell instance $22 r0 *1 0,80
X$22 PAD VSSIO esd_clamp_160
* cell instance $23 r0 *1 0,45
X$23 VSSIO \$440 VSSIO \$440 VSSIO \$440 VSSIO \$440 VSSIO \$440 VSSIO \$440
+ VSSIO \$440 VSSIO \$440 VSSIO \$440 VSSIO \$440 VSSIO \$440 VSSIO \$440 VSSIO
+ \$440 VSSIO \$440 VSSIO \$440 VSSIO \$440 VSSIO \$440 VSSIO \$440 VSSIO \$440
+ VSSIO \$440 VSSIO GN GN GN GN GN GN GN GN GN GN GN GN GN GN GN GN GN GN GN GN
+ GN GN GN GN GN GN GN GN GN GN GN GN GN GN GN GN GN GN GN GN VSSIO nfet
* cell instance $24 r0 *1 -1.58,59.6
X$24 VSSIO GP \$606 VSSIO nfet$10
* cell instance $25 r0 *1 13.42,59.6
X$25 VSSIO GN \$609 VSSIO nfet$14
* cell instance $26 r0 *1 -31.58,59.6
X$26 VSSIO \$600 OUT VSSIO nfet$2
* cell instance $27 r0 *1 5.52,59.6
X$27 VSSIO \$608 OUT VSSIO nfet$12
* cell instance $28 m90 *1 -23.58,59.6
X$28 \$602 \$571 PU_OK VSSIO nfet$4
* cell instance $29 r0 *1 -16.58,59.6
X$29 VSSIO \$604 \$571 VSSIO nfet$6
* cell instance $30 r0 *1 2.42,59.6
X$30 VSSIO \$608 \$571 VSSIO nfet$11
* cell instance $31 r0 *1 -27.58,59.6
X$31 VSSIO \$601 OE_N VSSIO nfet$3
* cell instance $32 r0 *1 -13.48,59.6
X$32 VSSIO \$604 \$600 VSSIO nfet$7
* cell instance $33 m90 *1 -20.48,59.6
X$33 VSSIO \$602 \$601 VSSIO nfet$5
* cell instance $34 r0 *1 -9.58,59.6
X$34 VSSIO \$605 \$604 VSSIO nfet$8
* cell instance $35 r0 *1 -5.58,59.6
X$35 VSSIO \$606 \$605 VSSIO nfet$9
* cell instance $36 r0 *1 9.42,59.6
X$36 VSSIO \$609 \$608 VSSIO nfet$13
.ENDS gf180_pad_core

* cell esd_clamp_160
* pin PAD
* pin VSSIO
.SUBCKT esd_clamp_160 PAD VSSIO
* cell instance $1 r0 *1 0,0
X$1 VSSIO PAD VSSIO PAD VSSIO PAD VSSIO PAD VSSIO PAD VSSIO PAD VSSIO PAD VSSIO
+ PAD VSSIO PAD VSSIO PAD VSSIO PAD VSSIO PAD VSSIO PAD VSSIO PAD VSSIO PAD
+ VSSIO PAD VSSIO PAD VSSIO PAD VSSIO PAD VSSIO PAD VSSIO VSSIO VSSIO VSSIO
+ VSSIO VSSIO VSSIO VSSIO VSSIO VSSIO VSSIO VSSIO VSSIO VSSIO VSSIO VSSIO VSSIO
+ VSSIO VSSIO VSSIO VSSIO VSSIO VSSIO VSSIO VSSIO VSSIO VSSIO VSSIO VSSIO VSSIO
+ VSSIO VSSIO VSSIO VSSIO VSSIO VSSIO VSSIO VSSIO VSSIO VSSIO VSSIO VSSIO
+ nfet$15
.ENDS esd_clamp_160

* cell nfet$14
* pin
* pin
* pin
* pin SUB
.SUBCKT nfet$14 \$1 \$2 \$4 SUB
* device instance $1 r0 *1 0.58,0.5 nfet_03v3
M$1 \$2 \$4 \$1 SUB nfet_03v3 L=0.28U W=1U AS=0.44P AD=0.44P PS=2.88U PD=2.88U
.ENDS nfet$14

* cell pmos$14
* pin
* pin
* pin
* pin
.SUBCKT pmos$14 \$1 \$2 \$3 \$4
* device instance $1 r0 *1 0.58,1 pfet_03v3
M$1 \$2 \$4 \$1 \$3 pfet_03v3 L=0.28U W=2U AS=0.88P AD=0.88P PS=4.88U PD=4.88U
.ENDS pmos$14

* cell nfet$13
* pin
* pin
* pin
* pin SUB
.SUBCKT nfet$13 \$1 \$2 \$4 SUB
* device instance $1 r0 *1 0.58,0.5 nfet_03v3
M$1 \$2 \$4 \$1 SUB nfet_03v3 L=0.28U W=1U AS=0.44P AD=0.44P PS=2.88U PD=2.88U
.ENDS nfet$13

* cell pmos$13
* pin
* pin
* pin
* pin
.SUBCKT pmos$13 \$1 \$2 \$3 \$4
* device instance $1 r0 *1 0.58,1 pfet_03v3
M$1 \$2 \$4 \$1 \$3 pfet_03v3 L=0.28U W=2U AS=0.88P AD=0.88P PS=4.88U PD=4.88U
.ENDS pmos$13

* cell nfet$12
* pin
* pin
* pin
* pin SUB
.SUBCKT nfet$12 \$1 \$2 \$4 SUB
* device instance $1 r0 *1 0.58,0.5 nfet_03v3
M$1 \$2 \$4 \$1 SUB nfet_03v3 L=0.28U W=1U AS=0.44P AD=0.44P PS=2.88U PD=2.88U
.ENDS nfet$12

* cell nfet$11
* pin
* pin
* pin
* pin SUB
.SUBCKT nfet$11 \$1 \$2 \$4 SUB
* device instance $1 r0 *1 0.58,0.5 nfet_03v3
M$1 \$2 \$4 \$1 SUB nfet_03v3 L=0.28U W=1U AS=0.44P AD=0.44P PS=2.88U PD=2.88U
.ENDS nfet$11

* cell pmos$12
* pin
* pin
* pin
* pin
.SUBCKT pmos$12 \$1 \$2 \$3 \$4
* device instance $1 r0 *1 0.58,1 pfet_03v3
M$1 \$2 \$4 \$1 \$3 pfet_03v3 L=0.28U W=2U AS=0.88P AD=0.88P PS=4.88U PD=4.88U
.ENDS pmos$12

* cell pmos$11
* pin
* pin
* pin
* pin
.SUBCKT pmos$11 \$1 \$2 \$3 \$4
* device instance $1 r0 *1 0.58,1 pfet_03v3
M$1 \$2 \$4 \$1 \$3 pfet_03v3 L=0.28U W=2U AS=0.88P AD=0.88P PS=4.88U PD=4.88U
.ENDS pmos$11

* cell nfet$10
* pin
* pin
* pin
* pin SUB
.SUBCKT nfet$10 \$1 \$2 \$4 SUB
* device instance $1 r0 *1 0.58,0.5 nfet_03v3
M$1 \$2 \$4 \$1 SUB nfet_03v3 L=0.28U W=1U AS=0.44P AD=0.44P PS=2.88U PD=2.88U
.ENDS nfet$10

* cell pmos$10
* pin
* pin
* pin
* pin
.SUBCKT pmos$10 \$1 \$2 \$3 \$4
* device instance $1 r0 *1 0.58,1 pfet_03v3
M$1 \$2 \$4 \$1 \$3 pfet_03v3 L=0.28U W=2U AS=0.88P AD=0.88P PS=4.88U PD=4.88U
.ENDS pmos$10

* cell nfet$9
* pin
* pin
* pin
* pin SUB
.SUBCKT nfet$9 \$1 \$2 \$4 SUB
* device instance $1 r0 *1 0.58,0.5 nfet_03v3
M$1 \$2 \$4 \$1 SUB nfet_03v3 L=0.28U W=1U AS=0.44P AD=0.44P PS=2.88U PD=2.88U
.ENDS nfet$9

* cell pmos$9
* pin
* pin
* pin
* pin
.SUBCKT pmos$9 \$1 \$2 \$3 \$4
* device instance $1 r0 *1 0.58,1 pfet_03v3
M$1 \$2 \$4 \$1 \$3 pfet_03v3 L=0.28U W=2U AS=0.88P AD=0.88P PS=4.88U PD=4.88U
.ENDS pmos$9

* cell nfet$8
* pin
* pin
* pin
* pin SUB
.SUBCKT nfet$8 \$1 \$2 \$4 SUB
* device instance $1 r0 *1 0.58,0.5 nfet_03v3
M$1 \$2 \$4 \$1 SUB nfet_03v3 L=0.28U W=1U AS=0.44P AD=0.44P PS=2.88U PD=2.88U
.ENDS nfet$8

* cell pmos$8
* pin
* pin
* pin
* pin
.SUBCKT pmos$8 \$1 \$2 \$3 \$4
* device instance $1 r0 *1 0.58,1 pfet_03v3
M$1 \$2 \$4 \$1 \$3 pfet_03v3 L=0.28U W=2U AS=0.88P AD=0.88P PS=4.88U PD=4.88U
.ENDS pmos$8

* cell nfet$7
* pin
* pin
* pin
* pin SUB
.SUBCKT nfet$7 \$1 \$2 \$4 SUB
* device instance $1 r0 *1 0.58,0.5 nfet_03v3
M$1 \$2 \$4 \$1 SUB nfet_03v3 L=0.28U W=1U AS=0.44P AD=0.44P PS=2.88U PD=2.88U
.ENDS nfet$7

* cell nfet$6
* pin
* pin
* pin
* pin SUB
.SUBCKT nfet$6 \$1 \$2 \$4 SUB
* device instance $1 r0 *1 0.58,0.5 nfet_03v3
M$1 \$2 \$4 \$1 SUB nfet_03v3 L=0.28U W=1U AS=0.44P AD=0.44P PS=2.88U PD=2.88U
.ENDS nfet$6

* cell pmos$7
* pin
* pin
* pin
* pin
.SUBCKT pmos$7 \$1 \$2 \$3 \$4
* device instance $1 r0 *1 0.58,1 pfet_03v3
M$1 \$2 \$4 \$1 \$3 pfet_03v3 L=0.28U W=2U AS=0.88P AD=0.88P PS=4.88U PD=4.88U
.ENDS pmos$7

* cell pmos$6
* pin
* pin
* pin
* pin
.SUBCKT pmos$6 \$1 \$2 \$3 \$4
* device instance $1 r0 *1 0.58,1 pfet_03v3
M$1 \$2 \$4 \$1 \$3 pfet_03v3 L=0.28U W=2U AS=0.88P AD=0.88P PS=4.88U PD=4.88U
.ENDS pmos$6

* cell nfet$5
* pin
* pin
* pin
* pin SUB
.SUBCKT nfet$5 \$1 \$2 \$4 SUB
* device instance $1 r0 *1 0.58,0.5 nfet_03v3
M$1 \$2 \$4 \$1 SUB nfet_03v3 L=0.28U W=1U AS=0.44P AD=0.44P PS=2.88U PD=2.88U
.ENDS nfet$5

* cell nfet$4
* pin
* pin
* pin
* pin SUB
.SUBCKT nfet$4 \$1 \$2 \$4 SUB
* device instance $1 r0 *1 0.58,0.5 nfet_03v3
M$1 \$2 \$4 \$1 SUB nfet_03v3 L=0.28U W=1U AS=0.44P AD=0.44P PS=2.88U PD=2.88U
.ENDS nfet$4

* cell pmos$5
* pin
* pin
* pin
* pin
.SUBCKT pmos$5 \$1 \$2 \$3 \$4
* device instance $1 r0 *1 0.58,1 pfet_03v3
M$1 \$2 \$4 \$1 \$3 pfet_03v3 L=0.28U W=2U AS=0.88P AD=0.88P PS=4.88U PD=4.88U
.ENDS pmos$5

* cell pmos$4
* pin
* pin
* pin
* pin
.SUBCKT pmos$4 \$1 \$2 \$3 \$4
* device instance $1 r0 *1 0.58,1 pfet_03v3
M$1 \$2 \$4 \$1 \$3 pfet_03v3 L=0.28U W=2U AS=0.88P AD=0.88P PS=4.88U PD=4.88U
.ENDS pmos$4

* cell nfet$3
* pin
* pin
* pin
* pin SUB
.SUBCKT nfet$3 \$1 \$2 \$4 SUB
* device instance $1 r0 *1 0.58,0.5 nfet_03v3
M$1 \$2 \$4 \$1 SUB nfet_03v3 L=0.28U W=1U AS=0.44P AD=0.44P PS=2.88U PD=2.88U
.ENDS nfet$3

* cell pmos$3
* pin
* pin
* pin
* pin
.SUBCKT pmos$3 \$1 \$2 \$3 \$4
* device instance $1 r0 *1 0.58,1 pfet_03v3
M$1 \$2 \$4 \$1 \$3 pfet_03v3 L=0.28U W=2U AS=0.88P AD=0.88P PS=4.88U PD=4.88U
.ENDS pmos$3

* cell nfet$2
* pin
* pin
* pin
* pin SUB
.SUBCKT nfet$2 \$1 \$2 \$4 SUB
* device instance $1 r0 *1 0.58,0.5 nfet_03v3
M$1 \$2 \$4 \$1 SUB nfet_03v3 L=0.28U W=1U AS=0.44P AD=0.44P PS=2.88U PD=2.88U
.ENDS nfet$2

* cell pmos$2
* pin
* pin
* pin
* pin
.SUBCKT pmos$2 \$1 \$2 \$3 \$4
* device instance $1 r0 *1 0.58,1 pfet_03v3
M$1 \$2 \$4 \$1 \$3 pfet_03v3 L=0.28U W=2U AS=0.88P AD=0.88P PS=4.88U PD=4.88U
.ENDS pmos$2

* cell pmos$1
* pin
* pin
* pin
* pin
.SUBCKT pmos$1 \$1 \$2 \$3 \$4
* device instance $1 r0 *1 0.58,2 pfet_03v3
M$1 \$2 \$4 \$1 \$3 pfet_03v3 L=0.28U W=4U AS=1.76P AD=1.76P PS=8.88U PD=8.88U
.ENDS pmos$1

* cell nfet$1
* pin
* pin
* pin
* pin SUB
.SUBCKT nfet$1 \$1 \$2 \$4 SUB
* device instance $1 r0 *1 0.58,1 nfet_03v3
M$1 \$2 \$4 \$1 SUB nfet_03v3 L=0.28U W=2U AS=0.88P AD=0.88P PS=4.88U PD=4.88U
.ENDS nfet$1

* cell diode_pn$1
* pin
* pin
.SUBCKT diode_pn$1 \$1 \$2
* device instance $1 r0 *1 5.84,5 diode_pd2nw_03v3
D$1 \$2 \$1 diode_pd2nw_03v3 A=100P P=40U
.ENDS diode_pn$1

* cell diode_np$1
* pin
* pin SUB
.SUBCKT diode_np$1 \$2 SUB
* device instance $1 r0 *1 4.84,4 diode_nd2ps_03v3
D$1 SUB \$2 diode_nd2ps_03v3 A=64P P=32U
.ENDS diode_np$1

* cell diode_np
* pin
* pin SUB
.SUBCKT diode_np \$2 SUB
* device instance $1 r0 *1 4.84,4 diode_nd2ps_03v3
D$1 SUB \$2 diode_nd2ps_03v3 A=64P P=32U
.ENDS diode_np

* cell diode_pn
* pin
* pin
.SUBCKT diode_pn \$1 \$2
* device instance $1 r0 *1 4.84,4 diode_pd2nw_03v3
D$1 \$2 \$1 diode_pd2nw_03v3 A=64P P=32U
.ENDS diode_pn

* cell ppolyf_u_resistor
* pin
* pin
* pin SUB
.SUBCKT ppolyf_u_resistor \$2 \$3 SUB
* device instance $1 r0 *1 0.7,11 ppolyf_u
R$1 \$2 \$3 SUB 22.2727272727 ppolyf_u L=1.4U W=22U
.ENDS ppolyf_u_resistor

* cell nfet
* pin
* pin
* pin
* pin
* pin
* pin
* pin
* pin
* pin
* pin
* pin
* pin
* pin
* pin
* pin
* pin
* pin
* pin
* pin
* pin
* pin
* pin
* pin
* pin
* pin
* pin
* pin
* pin
* pin
* pin
* pin
* pin
* pin
* pin
* pin
* pin
* pin
* pin
* pin
* pin
* pin
* pin
* pin
* pin
* pin
* pin
* pin
* pin
* pin
* pin
* pin
* pin
* pin
* pin
* pin
* pin
* pin
* pin
* pin
* pin
* pin
* pin
* pin
* pin
* pin
* pin
* pin
* pin
* pin
* pin
* pin
* pin
* pin
* pin
* pin
* pin
* pin
* pin
* pin
* pin
* pin
* pin SUB
.SUBCKT nfet \$2 \$3 \$4 \$5 \$6 \$7 \$8 \$9 \$10 \$11 \$12 \$13 \$14 \$15 \$16
+ \$17 \$18 \$19 \$20 \$21 \$22 \$23 \$24 \$25 \$26 \$27 \$28 \$29 \$30 \$31
+ \$32 \$33 \$34 \$35 \$36 \$37 \$38 \$39 \$40 \$41 \$42 \$43 \$44 \$45 \$46
+ \$47 \$48 \$49 \$50 \$51 \$52 \$53 \$54 \$55 \$56 \$57 \$58 \$59 \$60 \$61
+ \$62 \$63 \$64 \$65 \$66 \$67 \$68 \$69 \$70 \$71 \$72 \$73 \$74 \$75 \$76
+ \$77 \$78 \$79 \$80 \$81 \$82 SUB
* device instance $1 r0 *1 0.58,1 nfet_03v3
M$1 \$3 \$43 \$2 SUB nfet_03v3 L=0.28U W=2U AS=0.88P AD=0.52P PS=4.88U PD=2.52U
* device instance $2 r0 *1 1.38,1 nfet_03v3
M$2 \$4 \$44 \$3 SUB nfet_03v3 L=0.28U W=2U AS=0.52P AD=0.52P PS=2.52U PD=2.52U
* device instance $3 r0 *1 2.18,1 nfet_03v3
M$3 \$5 \$45 \$4 SUB nfet_03v3 L=0.28U W=2U AS=0.52P AD=0.52P PS=2.52U PD=2.52U
* device instance $4 r0 *1 2.98,1 nfet_03v3
M$4 \$6 \$46 \$5 SUB nfet_03v3 L=0.28U W=2U AS=0.52P AD=0.52P PS=2.52U PD=2.52U
* device instance $5 r0 *1 3.78,1 nfet_03v3
M$5 \$7 \$47 \$6 SUB nfet_03v3 L=0.28U W=2U AS=0.52P AD=0.52P PS=2.52U PD=2.52U
* device instance $6 r0 *1 4.58,1 nfet_03v3
M$6 \$8 \$48 \$7 SUB nfet_03v3 L=0.28U W=2U AS=0.52P AD=0.52P PS=2.52U PD=2.52U
* device instance $7 r0 *1 5.38,1 nfet_03v3
M$7 \$9 \$49 \$8 SUB nfet_03v3 L=0.28U W=2U AS=0.52P AD=0.52P PS=2.52U PD=2.52U
* device instance $8 r0 *1 6.18,1 nfet_03v3
M$8 \$10 \$50 \$9 SUB nfet_03v3 L=0.28U W=2U AS=0.52P AD=0.52P PS=2.52U PD=2.52U
* device instance $9 r0 *1 6.98,1 nfet_03v3
M$9 \$11 \$51 \$10 SUB nfet_03v3 L=0.28U W=2U AS=0.52P AD=0.52P PS=2.52U
+ PD=2.52U
* device instance $10 r0 *1 7.78,1 nfet_03v3
M$10 \$12 \$52 \$11 SUB nfet_03v3 L=0.28U W=2U AS=0.52P AD=0.52P PS=2.52U
+ PD=2.52U
* device instance $11 r0 *1 8.58,1 nfet_03v3
M$11 \$13 \$53 \$12 SUB nfet_03v3 L=0.28U W=2U AS=0.52P AD=0.52P PS=2.52U
+ PD=2.52U
* device instance $12 r0 *1 9.38,1 nfet_03v3
M$12 \$14 \$54 \$13 SUB nfet_03v3 L=0.28U W=2U AS=0.52P AD=0.52P PS=2.52U
+ PD=2.52U
* device instance $13 r0 *1 10.18,1 nfet_03v3
M$13 \$15 \$55 \$14 SUB nfet_03v3 L=0.28U W=2U AS=0.52P AD=0.52P PS=2.52U
+ PD=2.52U
* device instance $14 r0 *1 10.98,1 nfet_03v3
M$14 \$16 \$56 \$15 SUB nfet_03v3 L=0.28U W=2U AS=0.52P AD=0.52P PS=2.52U
+ PD=2.52U
* device instance $15 r0 *1 11.78,1 nfet_03v3
M$15 \$17 \$57 \$16 SUB nfet_03v3 L=0.28U W=2U AS=0.52P AD=0.52P PS=2.52U
+ PD=2.52U
* device instance $16 r0 *1 12.58,1 nfet_03v3
M$16 \$18 \$58 \$17 SUB nfet_03v3 L=0.28U W=2U AS=0.52P AD=0.52P PS=2.52U
+ PD=2.52U
* device instance $17 r0 *1 13.38,1 nfet_03v3
M$17 \$19 \$59 \$18 SUB nfet_03v3 L=0.28U W=2U AS=0.52P AD=0.52P PS=2.52U
+ PD=2.52U
* device instance $18 r0 *1 14.18,1 nfet_03v3
M$18 \$20 \$60 \$19 SUB nfet_03v3 L=0.28U W=2U AS=0.52P AD=0.52P PS=2.52U
+ PD=2.52U
* device instance $19 r0 *1 14.98,1 nfet_03v3
M$19 \$21 \$61 \$20 SUB nfet_03v3 L=0.28U W=2U AS=0.52P AD=0.52P PS=2.52U
+ PD=2.52U
* device instance $20 r0 *1 15.78,1 nfet_03v3
M$20 \$22 \$62 \$21 SUB nfet_03v3 L=0.28U W=2U AS=0.52P AD=0.52P PS=2.52U
+ PD=2.52U
* device instance $21 r0 *1 16.58,1 nfet_03v3
M$21 \$23 \$63 \$22 SUB nfet_03v3 L=0.28U W=2U AS=0.52P AD=0.52P PS=2.52U
+ PD=2.52U
* device instance $22 r0 *1 17.38,1 nfet_03v3
M$22 \$24 \$64 \$23 SUB nfet_03v3 L=0.28U W=2U AS=0.52P AD=0.52P PS=2.52U
+ PD=2.52U
* device instance $23 r0 *1 18.18,1 nfet_03v3
M$23 \$25 \$65 \$24 SUB nfet_03v3 L=0.28U W=2U AS=0.52P AD=0.52P PS=2.52U
+ PD=2.52U
* device instance $24 r0 *1 18.98,1 nfet_03v3
M$24 \$26 \$66 \$25 SUB nfet_03v3 L=0.28U W=2U AS=0.52P AD=0.52P PS=2.52U
+ PD=2.52U
* device instance $25 r0 *1 19.78,1 nfet_03v3
M$25 \$27 \$67 \$26 SUB nfet_03v3 L=0.28U W=2U AS=0.52P AD=0.52P PS=2.52U
+ PD=2.52U
* device instance $26 r0 *1 20.58,1 nfet_03v3
M$26 \$28 \$68 \$27 SUB nfet_03v3 L=0.28U W=2U AS=0.52P AD=0.52P PS=2.52U
+ PD=2.52U
* device instance $27 r0 *1 21.38,1 nfet_03v3
M$27 \$29 \$69 \$28 SUB nfet_03v3 L=0.28U W=2U AS=0.52P AD=0.52P PS=2.52U
+ PD=2.52U
* device instance $28 r0 *1 22.18,1 nfet_03v3
M$28 \$30 \$70 \$29 SUB nfet_03v3 L=0.28U W=2U AS=0.52P AD=0.52P PS=2.52U
+ PD=2.52U
* device instance $29 r0 *1 22.98,1 nfet_03v3
M$29 \$31 \$71 \$30 SUB nfet_03v3 L=0.28U W=2U AS=0.52P AD=0.52P PS=2.52U
+ PD=2.52U
* device instance $30 r0 *1 23.78,1 nfet_03v3
M$30 \$32 \$72 \$31 SUB nfet_03v3 L=0.28U W=2U AS=0.52P AD=0.52P PS=2.52U
+ PD=2.52U
* device instance $31 r0 *1 24.58,1 nfet_03v3
M$31 \$33 \$73 \$32 SUB nfet_03v3 L=0.28U W=2U AS=0.52P AD=0.52P PS=2.52U
+ PD=2.52U
* device instance $32 r0 *1 25.38,1 nfet_03v3
M$32 \$34 \$74 \$33 SUB nfet_03v3 L=0.28U W=2U AS=0.52P AD=0.52P PS=2.52U
+ PD=2.52U
* device instance $33 r0 *1 26.18,1 nfet_03v3
M$33 \$35 \$75 \$34 SUB nfet_03v3 L=0.28U W=2U AS=0.52P AD=0.52P PS=2.52U
+ PD=2.52U
* device instance $34 r0 *1 26.98,1 nfet_03v3
M$34 \$36 \$76 \$35 SUB nfet_03v3 L=0.28U W=2U AS=0.52P AD=0.52P PS=2.52U
+ PD=2.52U
* device instance $35 r0 *1 27.78,1 nfet_03v3
M$35 \$37 \$77 \$36 SUB nfet_03v3 L=0.28U W=2U AS=0.52P AD=0.52P PS=2.52U
+ PD=2.52U
* device instance $36 r0 *1 28.58,1 nfet_03v3
M$36 \$38 \$78 \$37 SUB nfet_03v3 L=0.28U W=2U AS=0.52P AD=0.52P PS=2.52U
+ PD=2.52U
* device instance $37 r0 *1 29.38,1 nfet_03v3
M$37 \$39 \$79 \$38 SUB nfet_03v3 L=0.28U W=2U AS=0.52P AD=0.52P PS=2.52U
+ PD=2.52U
* device instance $38 r0 *1 30.18,1 nfet_03v3
M$38 \$40 \$80 \$39 SUB nfet_03v3 L=0.28U W=2U AS=0.52P AD=0.52P PS=2.52U
+ PD=2.52U
* device instance $39 r0 *1 30.98,1 nfet_03v3
M$39 \$41 \$81 \$40 SUB nfet_03v3 L=0.28U W=2U AS=0.52P AD=0.52P PS=2.52U
+ PD=2.52U
* device instance $40 r0 *1 31.78,1 nfet_03v3
M$40 \$42 \$82 \$41 SUB nfet_03v3 L=0.28U W=2U AS=0.52P AD=0.88P PS=2.52U
+ PD=4.88U
.ENDS nfet

* cell pmos
* pin
* pin
* pin
* pin
* pin
* pin
* pin
* pin
* pin
* pin
* pin
* pin
* pin
* pin
* pin
* pin
* pin
* pin
* pin
* pin
* pin
* pin
* pin
* pin
* pin
* pin
* pin
* pin
* pin
* pin
* pin
* pin
* pin
* pin
* pin
* pin
* pin
* pin
* pin
* pin
* pin
* pin
* pin
* pin
* pin
* pin
* pin
* pin
* pin
* pin
* pin
* pin
* pin
* pin
* pin
* pin
* pin
* pin
* pin
* pin
* pin
* pin
* pin
* pin
* pin
* pin
* pin
* pin
* pin
* pin
* pin
* pin
* pin
* pin
* pin
* pin
* pin
* pin
* pin
* pin
* pin
* pin
.SUBCKT pmos \$1 \$2 \$3 \$4 \$5 \$6 \$7 \$8 \$9 \$10 \$11 \$12 \$13 \$14 \$15
+ \$16 \$17 \$18 \$19 \$20 \$21 \$22 \$23 \$24 \$25 \$26 \$27 \$28 \$29 \$30
+ \$31 \$32 \$33 \$34 \$35 \$36 \$37 \$38 \$39 \$40 \$41 \$42 \$43 \$44 \$45
+ \$46 \$47 \$48 \$49 \$50 \$51 \$52 \$53 \$54 \$55 \$56 \$57 \$58 \$59 \$60
+ \$61 \$62 \$63 \$64 \$65 \$66 \$67 \$68 \$69 \$70 \$71 \$72 \$73 \$74 \$75
+ \$76 \$77 \$78 \$79 \$80 \$81 \$82
* device instance $1 r0 *1 0.58,2.5 pfet_03v3
M$1 \$3 \$43 \$2 \$1 pfet_03v3 L=0.28U W=5U AS=2.2P AD=1.3P PS=10.88U PD=5.52U
* device instance $2 r0 *1 1.38,2.5 pfet_03v3
M$2 \$4 \$44 \$3 \$1 pfet_03v3 L=0.28U W=5U AS=1.3P AD=1.3P PS=5.52U PD=5.52U
* device instance $3 r0 *1 2.18,2.5 pfet_03v3
M$3 \$5 \$45 \$4 \$1 pfet_03v3 L=0.28U W=5U AS=1.3P AD=1.3P PS=5.52U PD=5.52U
* device instance $4 r0 *1 2.98,2.5 pfet_03v3
M$4 \$6 \$46 \$5 \$1 pfet_03v3 L=0.28U W=5U AS=1.3P AD=1.3P PS=5.52U PD=5.52U
* device instance $5 r0 *1 3.78,2.5 pfet_03v3
M$5 \$7 \$47 \$6 \$1 pfet_03v3 L=0.28U W=5U AS=1.3P AD=1.3P PS=5.52U PD=5.52U
* device instance $6 r0 *1 4.58,2.5 pfet_03v3
M$6 \$8 \$48 \$7 \$1 pfet_03v3 L=0.28U W=5U AS=1.3P AD=1.3P PS=5.52U PD=5.52U
* device instance $7 r0 *1 5.38,2.5 pfet_03v3
M$7 \$9 \$49 \$8 \$1 pfet_03v3 L=0.28U W=5U AS=1.3P AD=1.3P PS=5.52U PD=5.52U
* device instance $8 r0 *1 6.18,2.5 pfet_03v3
M$8 \$10 \$50 \$9 \$1 pfet_03v3 L=0.28U W=5U AS=1.3P AD=1.3P PS=5.52U PD=5.52U
* device instance $9 r0 *1 6.98,2.5 pfet_03v3
M$9 \$11 \$51 \$10 \$1 pfet_03v3 L=0.28U W=5U AS=1.3P AD=1.3P PS=5.52U PD=5.52U
* device instance $10 r0 *1 7.78,2.5 pfet_03v3
M$10 \$12 \$52 \$11 \$1 pfet_03v3 L=0.28U W=5U AS=1.3P AD=1.3P PS=5.52U PD=5.52U
* device instance $11 r0 *1 8.58,2.5 pfet_03v3
M$11 \$13 \$53 \$12 \$1 pfet_03v3 L=0.28U W=5U AS=1.3P AD=1.3P PS=5.52U PD=5.52U
* device instance $12 r0 *1 9.38,2.5 pfet_03v3
M$12 \$14 \$54 \$13 \$1 pfet_03v3 L=0.28U W=5U AS=1.3P AD=1.3P PS=5.52U PD=5.52U
* device instance $13 r0 *1 10.18,2.5 pfet_03v3
M$13 \$15 \$55 \$14 \$1 pfet_03v3 L=0.28U W=5U AS=1.3P AD=1.3P PS=5.52U PD=5.52U
* device instance $14 r0 *1 10.98,2.5 pfet_03v3
M$14 \$16 \$56 \$15 \$1 pfet_03v3 L=0.28U W=5U AS=1.3P AD=1.3P PS=5.52U PD=5.52U
* device instance $15 r0 *1 11.78,2.5 pfet_03v3
M$15 \$17 \$57 \$16 \$1 pfet_03v3 L=0.28U W=5U AS=1.3P AD=1.3P PS=5.52U PD=5.52U
* device instance $16 r0 *1 12.58,2.5 pfet_03v3
M$16 \$18 \$58 \$17 \$1 pfet_03v3 L=0.28U W=5U AS=1.3P AD=1.3P PS=5.52U PD=5.52U
* device instance $17 r0 *1 13.38,2.5 pfet_03v3
M$17 \$19 \$59 \$18 \$1 pfet_03v3 L=0.28U W=5U AS=1.3P AD=1.3P PS=5.52U PD=5.52U
* device instance $18 r0 *1 14.18,2.5 pfet_03v3
M$18 \$20 \$60 \$19 \$1 pfet_03v3 L=0.28U W=5U AS=1.3P AD=1.3P PS=5.52U PD=5.52U
* device instance $19 r0 *1 14.98,2.5 pfet_03v3
M$19 \$21 \$61 \$20 \$1 pfet_03v3 L=0.28U W=5U AS=1.3P AD=1.3P PS=5.52U PD=5.52U
* device instance $20 r0 *1 15.78,2.5 pfet_03v3
M$20 \$22 \$62 \$21 \$1 pfet_03v3 L=0.28U W=5U AS=1.3P AD=1.3P PS=5.52U PD=5.52U
* device instance $21 r0 *1 16.58,2.5 pfet_03v3
M$21 \$23 \$63 \$22 \$1 pfet_03v3 L=0.28U W=5U AS=1.3P AD=1.3P PS=5.52U PD=5.52U
* device instance $22 r0 *1 17.38,2.5 pfet_03v3
M$22 \$24 \$64 \$23 \$1 pfet_03v3 L=0.28U W=5U AS=1.3P AD=1.3P PS=5.52U PD=5.52U
* device instance $23 r0 *1 18.18,2.5 pfet_03v3
M$23 \$25 \$65 \$24 \$1 pfet_03v3 L=0.28U W=5U AS=1.3P AD=1.3P PS=5.52U PD=5.52U
* device instance $24 r0 *1 18.98,2.5 pfet_03v3
M$24 \$26 \$66 \$25 \$1 pfet_03v3 L=0.28U W=5U AS=1.3P AD=1.3P PS=5.52U PD=5.52U
* device instance $25 r0 *1 19.78,2.5 pfet_03v3
M$25 \$27 \$67 \$26 \$1 pfet_03v3 L=0.28U W=5U AS=1.3P AD=1.3P PS=5.52U PD=5.52U
* device instance $26 r0 *1 20.58,2.5 pfet_03v3
M$26 \$28 \$68 \$27 \$1 pfet_03v3 L=0.28U W=5U AS=1.3P AD=1.3P PS=5.52U PD=5.52U
* device instance $27 r0 *1 21.38,2.5 pfet_03v3
M$27 \$29 \$69 \$28 \$1 pfet_03v3 L=0.28U W=5U AS=1.3P AD=1.3P PS=5.52U PD=5.52U
* device instance $28 r0 *1 22.18,2.5 pfet_03v3
M$28 \$30 \$70 \$29 \$1 pfet_03v3 L=0.28U W=5U AS=1.3P AD=1.3P PS=5.52U PD=5.52U
* device instance $29 r0 *1 22.98,2.5 pfet_03v3
M$29 \$31 \$71 \$30 \$1 pfet_03v3 L=0.28U W=5U AS=1.3P AD=1.3P PS=5.52U PD=5.52U
* device instance $30 r0 *1 23.78,2.5 pfet_03v3
M$30 \$32 \$72 \$31 \$1 pfet_03v3 L=0.28U W=5U AS=1.3P AD=1.3P PS=5.52U PD=5.52U
* device instance $31 r0 *1 24.58,2.5 pfet_03v3
M$31 \$33 \$73 \$32 \$1 pfet_03v3 L=0.28U W=5U AS=1.3P AD=1.3P PS=5.52U PD=5.52U
* device instance $32 r0 *1 25.38,2.5 pfet_03v3
M$32 \$34 \$74 \$33 \$1 pfet_03v3 L=0.28U W=5U AS=1.3P AD=1.3P PS=5.52U PD=5.52U
* device instance $33 r0 *1 26.18,2.5 pfet_03v3
M$33 \$35 \$75 \$34 \$1 pfet_03v3 L=0.28U W=5U AS=1.3P AD=1.3P PS=5.52U PD=5.52U
* device instance $34 r0 *1 26.98,2.5 pfet_03v3
M$34 \$36 \$76 \$35 \$1 pfet_03v3 L=0.28U W=5U AS=1.3P AD=1.3P PS=5.52U PD=5.52U
* device instance $35 r0 *1 27.78,2.5 pfet_03v3
M$35 \$37 \$77 \$36 \$1 pfet_03v3 L=0.28U W=5U AS=1.3P AD=1.3P PS=5.52U PD=5.52U
* device instance $36 r0 *1 28.58,2.5 pfet_03v3
M$36 \$38 \$78 \$37 \$1 pfet_03v3 L=0.28U W=5U AS=1.3P AD=1.3P PS=5.52U PD=5.52U
* device instance $37 r0 *1 29.38,2.5 pfet_03v3
M$37 \$39 \$79 \$38 \$1 pfet_03v3 L=0.28U W=5U AS=1.3P AD=1.3P PS=5.52U PD=5.52U
* device instance $38 r0 *1 30.18,2.5 pfet_03v3
M$38 \$40 \$80 \$39 \$1 pfet_03v3 L=0.28U W=5U AS=1.3P AD=1.3P PS=5.52U PD=5.52U
* device instance $39 r0 *1 30.98,2.5 pfet_03v3
M$39 \$41 \$81 \$40 \$1 pfet_03v3 L=0.28U W=5U AS=1.3P AD=1.3P PS=5.52U PD=5.52U
* device instance $40 r0 *1 31.78,2.5 pfet_03v3
M$40 \$42 \$82 \$41 \$1 pfet_03v3 L=0.28U W=5U AS=1.3P AD=2.2P PS=5.52U
+ PD=10.88U
.ENDS pmos

* cell nfet$15
* pin
* pin
* pin
* pin
* pin
* pin
* pin
* pin
* pin
* pin
* pin
* pin
* pin
* pin
* pin
* pin
* pin
* pin
* pin
* pin
* pin
* pin
* pin
* pin
* pin
* pin
* pin
* pin
* pin
* pin
* pin
* pin
* pin
* pin
* pin
* pin
* pin
* pin
* pin
* pin
* pin
* pin
* pin
* pin
* pin
* pin
* pin
* pin
* pin
* pin
* pin
* pin
* pin
* pin
* pin
* pin
* pin
* pin
* pin
* pin
* pin
* pin
* pin
* pin
* pin
* pin
* pin
* pin
* pin
* pin
* pin
* pin
* pin
* pin
* pin
* pin
* pin
* pin
* pin
* pin
* pin
* pin SUB
.SUBCKT nfet$15 \$2 \$3 \$4 \$5 \$6 \$7 \$8 \$9 \$10 \$11 \$12 \$13 \$14 \$15
+ \$16 \$17 \$18 \$19 \$20 \$21 \$22 \$23 \$24 \$25 \$26 \$27 \$28 \$29 \$30
+ \$31 \$32 \$33 \$34 \$35 \$36 \$37 \$38 \$39 \$40 \$41 \$42 \$43 \$44 \$45
+ \$46 \$47 \$48 \$49 \$50 \$51 \$52 \$53 \$54 \$55 \$56 \$57 \$58 \$59 \$60
+ \$61 \$62 \$63 \$64 \$65 \$66 \$67 \$68 \$69 \$70 \$71 \$72 \$73 \$74 \$75
+ \$76 \$77 \$78 \$79 \$80 \$81 \$82 SUB
* device instance $1 r0 *1 0.58,2 nfet_03v3
M$1 \$3 \$43 \$2 SUB nfet_03v3 L=0.28U W=4U AS=1.76P AD=1.04P PS=8.88U PD=4.52U
* device instance $2 r0 *1 1.38,2 nfet_03v3
M$2 \$4 \$44 \$3 SUB nfet_03v3 L=0.28U W=4U AS=1.04P AD=1.04P PS=4.52U PD=4.52U
* device instance $3 r0 *1 2.18,2 nfet_03v3
M$3 \$5 \$45 \$4 SUB nfet_03v3 L=0.28U W=4U AS=1.04P AD=1.04P PS=4.52U PD=4.52U
* device instance $4 r0 *1 2.98,2 nfet_03v3
M$4 \$6 \$46 \$5 SUB nfet_03v3 L=0.28U W=4U AS=1.04P AD=1.04P PS=4.52U PD=4.52U
* device instance $5 r0 *1 3.78,2 nfet_03v3
M$5 \$7 \$47 \$6 SUB nfet_03v3 L=0.28U W=4U AS=1.04P AD=1.04P PS=4.52U PD=4.52U
* device instance $6 r0 *1 4.58,2 nfet_03v3
M$6 \$8 \$48 \$7 SUB nfet_03v3 L=0.28U W=4U AS=1.04P AD=1.04P PS=4.52U PD=4.52U
* device instance $7 r0 *1 5.38,2 nfet_03v3
M$7 \$9 \$49 \$8 SUB nfet_03v3 L=0.28U W=4U AS=1.04P AD=1.04P PS=4.52U PD=4.52U
* device instance $8 r0 *1 6.18,2 nfet_03v3
M$8 \$10 \$50 \$9 SUB nfet_03v3 L=0.28U W=4U AS=1.04P AD=1.04P PS=4.52U PD=4.52U
* device instance $9 r0 *1 6.98,2 nfet_03v3
M$9 \$11 \$51 \$10 SUB nfet_03v3 L=0.28U W=4U AS=1.04P AD=1.04P PS=4.52U
+ PD=4.52U
* device instance $10 r0 *1 7.78,2 nfet_03v3
M$10 \$12 \$52 \$11 SUB nfet_03v3 L=0.28U W=4U AS=1.04P AD=1.04P PS=4.52U
+ PD=4.52U
* device instance $11 r0 *1 8.58,2 nfet_03v3
M$11 \$13 \$53 \$12 SUB nfet_03v3 L=0.28U W=4U AS=1.04P AD=1.04P PS=4.52U
+ PD=4.52U
* device instance $12 r0 *1 9.38,2 nfet_03v3
M$12 \$14 \$54 \$13 SUB nfet_03v3 L=0.28U W=4U AS=1.04P AD=1.04P PS=4.52U
+ PD=4.52U
* device instance $13 r0 *1 10.18,2 nfet_03v3
M$13 \$15 \$55 \$14 SUB nfet_03v3 L=0.28U W=4U AS=1.04P AD=1.04P PS=4.52U
+ PD=4.52U
* device instance $14 r0 *1 10.98,2 nfet_03v3
M$14 \$16 \$56 \$15 SUB nfet_03v3 L=0.28U W=4U AS=1.04P AD=1.04P PS=4.52U
+ PD=4.52U
* device instance $15 r0 *1 11.78,2 nfet_03v3
M$15 \$17 \$57 \$16 SUB nfet_03v3 L=0.28U W=4U AS=1.04P AD=1.04P PS=4.52U
+ PD=4.52U
* device instance $16 r0 *1 12.58,2 nfet_03v3
M$16 \$18 \$58 \$17 SUB nfet_03v3 L=0.28U W=4U AS=1.04P AD=1.04P PS=4.52U
+ PD=4.52U
* device instance $17 r0 *1 13.38,2 nfet_03v3
M$17 \$19 \$59 \$18 SUB nfet_03v3 L=0.28U W=4U AS=1.04P AD=1.04P PS=4.52U
+ PD=4.52U
* device instance $18 r0 *1 14.18,2 nfet_03v3
M$18 \$20 \$60 \$19 SUB nfet_03v3 L=0.28U W=4U AS=1.04P AD=1.04P PS=4.52U
+ PD=4.52U
* device instance $19 r0 *1 14.98,2 nfet_03v3
M$19 \$21 \$61 \$20 SUB nfet_03v3 L=0.28U W=4U AS=1.04P AD=1.04P PS=4.52U
+ PD=4.52U
* device instance $20 r0 *1 15.78,2 nfet_03v3
M$20 \$22 \$62 \$21 SUB nfet_03v3 L=0.28U W=4U AS=1.04P AD=1.04P PS=4.52U
+ PD=4.52U
* device instance $21 r0 *1 16.58,2 nfet_03v3
M$21 \$23 \$63 \$22 SUB nfet_03v3 L=0.28U W=4U AS=1.04P AD=1.04P PS=4.52U
+ PD=4.52U
* device instance $22 r0 *1 17.38,2 nfet_03v3
M$22 \$24 \$64 \$23 SUB nfet_03v3 L=0.28U W=4U AS=1.04P AD=1.04P PS=4.52U
+ PD=4.52U
* device instance $23 r0 *1 18.18,2 nfet_03v3
M$23 \$25 \$65 \$24 SUB nfet_03v3 L=0.28U W=4U AS=1.04P AD=1.04P PS=4.52U
+ PD=4.52U
* device instance $24 r0 *1 18.98,2 nfet_03v3
M$24 \$26 \$66 \$25 SUB nfet_03v3 L=0.28U W=4U AS=1.04P AD=1.04P PS=4.52U
+ PD=4.52U
* device instance $25 r0 *1 19.78,2 nfet_03v3
M$25 \$27 \$67 \$26 SUB nfet_03v3 L=0.28U W=4U AS=1.04P AD=1.04P PS=4.52U
+ PD=4.52U
* device instance $26 r0 *1 20.58,2 nfet_03v3
M$26 \$28 \$68 \$27 SUB nfet_03v3 L=0.28U W=4U AS=1.04P AD=1.04P PS=4.52U
+ PD=4.52U
* device instance $27 r0 *1 21.38,2 nfet_03v3
M$27 \$29 \$69 \$28 SUB nfet_03v3 L=0.28U W=4U AS=1.04P AD=1.04P PS=4.52U
+ PD=4.52U
* device instance $28 r0 *1 22.18,2 nfet_03v3
M$28 \$30 \$70 \$29 SUB nfet_03v3 L=0.28U W=4U AS=1.04P AD=1.04P PS=4.52U
+ PD=4.52U
* device instance $29 r0 *1 22.98,2 nfet_03v3
M$29 \$31 \$71 \$30 SUB nfet_03v3 L=0.28U W=4U AS=1.04P AD=1.04P PS=4.52U
+ PD=4.52U
* device instance $30 r0 *1 23.78,2 nfet_03v3
M$30 \$32 \$72 \$31 SUB nfet_03v3 L=0.28U W=4U AS=1.04P AD=1.04P PS=4.52U
+ PD=4.52U
* device instance $31 r0 *1 24.58,2 nfet_03v3
M$31 \$33 \$73 \$32 SUB nfet_03v3 L=0.28U W=4U AS=1.04P AD=1.04P PS=4.52U
+ PD=4.52U
* device instance $32 r0 *1 25.38,2 nfet_03v3
M$32 \$34 \$74 \$33 SUB nfet_03v3 L=0.28U W=4U AS=1.04P AD=1.04P PS=4.52U
+ PD=4.52U
* device instance $33 r0 *1 26.18,2 nfet_03v3
M$33 \$35 \$75 \$34 SUB nfet_03v3 L=0.28U W=4U AS=1.04P AD=1.04P PS=4.52U
+ PD=4.52U
* device instance $34 r0 *1 26.98,2 nfet_03v3
M$34 \$36 \$76 \$35 SUB nfet_03v3 L=0.28U W=4U AS=1.04P AD=1.04P PS=4.52U
+ PD=4.52U
* device instance $35 r0 *1 27.78,2 nfet_03v3
M$35 \$37 \$77 \$36 SUB nfet_03v3 L=0.28U W=4U AS=1.04P AD=1.04P PS=4.52U
+ PD=4.52U
* device instance $36 r0 *1 28.58,2 nfet_03v3
M$36 \$38 \$78 \$37 SUB nfet_03v3 L=0.28U W=4U AS=1.04P AD=1.04P PS=4.52U
+ PD=4.52U
* device instance $37 r0 *1 29.38,2 nfet_03v3
M$37 \$39 \$79 \$38 SUB nfet_03v3 L=0.28U W=4U AS=1.04P AD=1.04P PS=4.52U
+ PD=4.52U
* device instance $38 r0 *1 30.18,2 nfet_03v3
M$38 \$40 \$80 \$39 SUB nfet_03v3 L=0.28U W=4U AS=1.04P AD=1.04P PS=4.52U
+ PD=4.52U
* device instance $39 r0 *1 30.98,2 nfet_03v3
M$39 \$41 \$81 \$40 SUB nfet_03v3 L=0.28U W=4U AS=1.04P AD=1.04P PS=4.52U
+ PD=4.52U
* device instance $40 r0 *1 31.78,2 nfet_03v3
M$40 \$42 \$82 \$41 SUB nfet_03v3 L=0.28U W=4U AS=1.04P AD=1.76P PS=4.52U
+ PD=8.88U
.ENDS nfet$15
