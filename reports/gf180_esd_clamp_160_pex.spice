* SPICE3 file created from gf180_esd_clamp_160_flat.ext - technology: gf180mcuD

.option scale=5n

X0 PAD VSSIO.t72 VSSIO VSSIO nfet_03v3 ad=41.6n pd=0.904m as=41.6n ps=0.904m w=800 l=56
X1 VSSIO VSSIO.t63 PAD VSSIO nfet_03v3 ad=41.6n pd=0.904m as=41.6n ps=0.904m w=800 l=56
X2 PAD VSSIO.t54 VSSIO VSSIO nfet_03v3 ad=41.6n pd=0.904m as=41.6n ps=0.904m w=800 l=56
X3 VSSIO VSSIO.t45 PAD VSSIO nfet_03v3 ad=41.6n pd=0.904m as=41.6n ps=0.904m w=800 l=56
X4 VSSIO VSSIO.t51 PAD VSSIO nfet_03v3 ad=41.6n pd=0.904m as=41.6n ps=0.904m w=800 l=56
X5 VSSIO VSSIO.t117 PAD VSSIO nfet_03v3 ad=70.4n pd=1.776m as=41.6n ps=0.904m w=800 l=56
X6 VSSIO VSSIO.t9 PAD VSSIO nfet_03v3 ad=41.6n pd=0.904m as=41.6n ps=0.904m w=800 l=56
X7 PAD VSSIO.t42 VSSIO VSSIO nfet_03v3 ad=41.6n pd=0.904m as=41.6n ps=0.904m w=800 l=56
X8 PAD VSSIO.t6 VSSIO VSSIO nfet_03v3 ad=41.6n pd=0.904m as=41.6n ps=0.904m w=800 l=56
X9 PAD VSSIO.t108 VSSIO VSSIO nfet_03v3 ad=41.6n pd=0.904m as=41.6n ps=0.904m w=800 l=56
X10 VSSIO VSSIO.t33 PAD VSSIO nfet_03v3 ad=41.6n pd=0.904m as=41.6n ps=0.904m w=800 l=56
X11 PAD VSSIO.t24 VSSIO VSSIO nfet_03v3 ad=41.6n pd=0.904m as=41.6n ps=0.904m w=800 l=56
X12 VSSIO VSSIO.t99 PAD VSSIO nfet_03v3 ad=41.6n pd=0.904m as=41.6n ps=0.904m w=800 l=56
X13 VSSIO VSSIO.t21 PAD VSSIO nfet_03v3 ad=41.6n pd=0.904m as=41.6n ps=0.904m w=800 l=56
X14 PAD VSSIO.t96 VSSIO VSSIO nfet_03v3 ad=41.6n pd=0.904m as=41.6n ps=0.904m w=800 l=56
X15 PAD VSSIO.t90 VSSIO VSSIO nfet_03v3 ad=41.6n pd=0.904m as=41.6n ps=0.904m w=800 l=56
X16 VSSIO VSSIO.t87 PAD VSSIO nfet_03v3 ad=41.6n pd=0.904m as=41.6n ps=0.904m w=800 l=56
X17 PAD VSSIO.t78 VSSIO VSSIO nfet_03v3 ad=41.6n pd=0.904m as=41.6n ps=0.904m w=800 l=56
X18 VSSIO VSSIO.t69 PAD VSSIO nfet_03v3 ad=41.6n pd=0.904m as=41.6n ps=0.904m w=800 l=56
X19 PAD VSSIO.t60 VSSIO VSSIO nfet_03v3 ad=41.6n pd=0.904m as=41.6n ps=0.904m w=800 l=56
X20 PAD VSSIO.t66 VSSIO VSSIO nfet_03v3 ad=41.6n pd=0.904m as=41.6n ps=0.904m w=800 l=56
X21 VSSIO VSSIO.t57 PAD VSSIO nfet_03v3 ad=41.6n pd=0.904m as=41.6n ps=0.904m w=800 l=56
X22 PAD VSSIO.t0 VSSIO VSSIO nfet_03v3 ad=41.6n pd=0.904m as=70.4n ps=1.776m w=800 l=56
X23 VSSIO VSSIO.t15 PAD VSSIO nfet_03v3 ad=41.6n pd=0.904m as=41.6n ps=0.904m w=800 l=56
X24 PAD VSSIO.t48 VSSIO VSSIO nfet_03v3 ad=41.6n pd=0.904m as=41.6n ps=0.904m w=800 l=56
X25 PAD VSSIO.t114 VSSIO VSSIO nfet_03v3 ad=41.6n pd=0.904m as=41.6n ps=0.904m w=800 l=56
X26 PAD VSSIO.t12 VSSIO VSSIO nfet_03v3 ad=41.6n pd=0.904m as=41.6n ps=0.904m w=800 l=56
X27 VSSIO VSSIO.t39 PAD VSSIO nfet_03v3 ad=41.6n pd=0.904m as=41.6n ps=0.904m w=800 l=56
X28 VSSIO VSSIO.t111 PAD VSSIO nfet_03v3 ad=41.6n pd=0.904m as=41.6n ps=0.904m w=800 l=56
X29 VSSIO VSSIO.t3 PAD VSSIO nfet_03v3 ad=41.6n pd=0.904m as=41.6n ps=0.904m w=800 l=56
X30 PAD VSSIO.t36 VSSIO VSSIO nfet_03v3 ad=41.6n pd=0.904m as=41.6n ps=0.904m w=800 l=56
X31 VSSIO VSSIO.t105 PAD VSSIO nfet_03v3 ad=41.6n pd=0.904m as=41.6n ps=0.904m w=800 l=56
X32 PAD VSSIO.t30 VSSIO VSSIO nfet_03v3 ad=41.6n pd=0.904m as=41.6n ps=0.904m w=800 l=56
X33 VSSIO VSSIO.t27 PAD VSSIO nfet_03v3 ad=41.6n pd=0.904m as=41.6n ps=0.904m w=800 l=56
X34 PAD VSSIO.t102 VSSIO VSSIO nfet_03v3 ad=41.6n pd=0.904m as=41.6n ps=0.904m w=800 l=56
X35 PAD VSSIO.t18 VSSIO VSSIO nfet_03v3 ad=41.6n pd=0.904m as=41.6n ps=0.904m w=800 l=56
X36 VSSIO VSSIO.t93 PAD VSSIO nfet_03v3 ad=41.6n pd=0.904m as=41.6n ps=0.904m w=800 l=56
X37 PAD VSSIO.t84 VSSIO VSSIO nfet_03v3 ad=41.6n pd=0.904m as=41.6n ps=0.904m w=800 l=56
X38 VSSIO VSSIO.t75 PAD VSSIO nfet_03v3 ad=41.6n pd=0.904m as=41.6n ps=0.904m w=800 l=56
X39 VSSIO VSSIO.t81 PAD VSSIO nfet_03v3 ad=41.6n pd=0.904m as=41.6n ps=0.904m w=800 l=56
R0 VSSIO.n0 VSSIO.t117 70.3412
R1 VSSIO.n0 VSSIO.t114 58.6612
R2 VSSIO.n1 VSSIO.t111 58.6612
R3 VSSIO.n2 VSSIO.t108 58.6612
R4 VSSIO.n3 VSSIO.t105 58.6612
R5 VSSIO.n4 VSSIO.t102 58.6612
R6 VSSIO.n5 VSSIO.t99 58.6612
R7 VSSIO.n6 VSSIO.t96 58.6612
R8 VSSIO.n7 VSSIO.t93 58.6612
R9 VSSIO.n8 VSSIO.t90 58.6612
R10 VSSIO.n9 VSSIO.t87 58.6612
R11 VSSIO.n10 VSSIO.t84 58.6612
R12 VSSIO.n11 VSSIO.t81 58.6612
R13 VSSIO.n12 VSSIO.t78 58.6612
R14 VSSIO.n13 VSSIO.t75 58.6612
R15 VSSIO.n14 VSSIO.t72 58.6612
R16 VSSIO.n15 VSSIO.t69 58.6612
R17 VSSIO.n16 VSSIO.t66 58.6612
R18 VSSIO.n17 VSSIO.t63 58.6612
R19 VSSIO.n18 VSSIO.t60 58.6612
R20 VSSIO.n19 VSSIO.t57 58.6612
R21 VSSIO.n20 VSSIO.t54 58.6612
R22 VSSIO.n21 VSSIO.t51 58.6612
R23 VSSIO.n22 VSSIO.t48 58.6612
R24 VSSIO.n23 VSSIO.t45 58.6612
R25 VSSIO.n24 VSSIO.t42 58.6612
R26 VSSIO.n25 VSSIO.t39 58.6612
R27 VSSIO.n26 VSSIO.t36 58.6612
R28 VSSIO.n27 VSSIO.t33 58.6612
R29 VSSIO.n28 VSSIO.t30 58.6612
R30 VSSIO.n29 VSSIO.t27 58.6612
R31 VSSIO.n30 VSSIO.t24 58.6612
R32 VSSIO.n31 VSSIO.t21 58.6612
R33 VSSIO.n32 VSSIO.t18 58.6612
R34 VSSIO.n33 VSSIO.t15 58.6612
R35 VSSIO.n34 VSSIO.t12 58.6612
R36 VSSIO.n35 VSSIO.t9 58.6612
R37 VSSIO.n36 VSSIO.t6 58.6612
R38 VSSIO.n37 VSSIO.t3 58.6612
R39 VSSIO.n38 VSSIO.t0 58.6612
R40 VSSIO VSSIO.n38 38.2495
R41 VSSIO.n38 VSSIO.n37 11.6805
R42 VSSIO.n37 VSSIO.n36 11.6805
R43 VSSIO.n36 VSSIO.n35 11.6805
R44 VSSIO.n35 VSSIO.n34 11.6805
R45 VSSIO.n34 VSSIO.n33 11.6805
R46 VSSIO.n33 VSSIO.n32 11.6805
R47 VSSIO.n32 VSSIO.n31 11.6805
R48 VSSIO.n31 VSSIO.n30 11.6805
R49 VSSIO.n30 VSSIO.n29 11.6805
R50 VSSIO.n29 VSSIO.n28 11.6805
R51 VSSIO.n28 VSSIO.n27 11.6805
R52 VSSIO.n27 VSSIO.n26 11.6805
R53 VSSIO.n26 VSSIO.n25 11.6805
R54 VSSIO.n25 VSSIO.n24 11.6805
R55 VSSIO.n24 VSSIO.n23 11.6805
R56 VSSIO.n23 VSSIO.n22 11.6805
R57 VSSIO.n22 VSSIO.n21 11.6805
R58 VSSIO.n21 VSSIO.n20 11.6805
R59 VSSIO.n20 VSSIO.n19 11.6805
R60 VSSIO.n19 VSSIO.n18 11.6805
R61 VSSIO.n18 VSSIO.n17 11.6805
R62 VSSIO.n17 VSSIO.n16 11.6805
R63 VSSIO.n16 VSSIO.n15 11.6805
R64 VSSIO.n15 VSSIO.n14 11.6805
R65 VSSIO.n14 VSSIO.n13 11.6805
R66 VSSIO.n13 VSSIO.n12 11.6805
R67 VSSIO.n12 VSSIO.n11 11.6805
R68 VSSIO.n11 VSSIO.n10 11.6805
R69 VSSIO.n10 VSSIO.n9 11.6805
R70 VSSIO.n9 VSSIO.n8 11.6805
R71 VSSIO.n8 VSSIO.n7 11.6805
R72 VSSIO.n7 VSSIO.n6 11.6805
R73 VSSIO.n6 VSSIO.n5 11.6805
R74 VSSIO.n5 VSSIO.n4 11.6805
R75 VSSIO.n4 VSSIO.n3 11.6805
R76 VSSIO.n3 VSSIO.n2 11.6805
R77 VSSIO.n2 VSSIO.n1 11.6805
R78 VSSIO.n1 VSSIO.n0 11.6805
C0 PAD VSSIO 16.3657f
