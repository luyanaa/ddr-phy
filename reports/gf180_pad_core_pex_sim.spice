* SPICE3 file created from gf180_pad_core_flat.ext - technology: gf180mcuD

.subckt gf180_pad_core_flat GP GN PAD VSSIO VDDIO IN OUT OE_N PU_OK
X0 a_n7856_9000_t16 GP_t25 VDDIO_t41 VDDIO_t40 pfet_03v3 ad=52n pd=1.104m as=52n ps=1.104m w=5e-06 l=2.8e-07
X1 VSSIO_t193 VSSIO_t191 PAD_t36 VSSIO_t192 nfet_03v3 ad=20.8n pd=0.504m as=20.8n ps=0.504m w=2e-06 l=2.8e-07
X2 VSSIO_t127 VSSIO_t125 PAD_t18 VSSIO_t126 nfet_03v3 ad=20.8n pd=0.504m as=20.8n ps=0.504m w=2e-06 l=2.8e-07
X3 PAD_t3 VSSIO_t101 VSSIO_t103 VSSIO_t102 nfet_03v3 ad=20.8n pd=0.504m as=20.8n ps=0.504m w=2e-06 l=2.8e-07
X4 VSSIO_t74 GN_t2 a_n7856_9000_t79 VSSIO_t73 nfet_03v3 ad=35.2n pd=0.976m as=20.8n ps=0.504m w=2e-06 l=2.8e-07
X5 PAD_t23 VSSIO_t152 VSSIO_t154 VSSIO_t153 nfet_03v3 ad=20.8n pd=0.504m as=20.8n ps=0.504m w=2e-06 l=2.8e-07
X6 PAD_t15 VSSIO_t137 VSSIO_t139 VSSIO_t138 nfet_03v3 ad=20.8n pd=0.504m as=20.8n ps=0.504m w=2e-06 l=2.8e-07
X7 a_n7856_9000_t56 GN_t25 VSSIO_t33 VSSIO_t32 nfet_03v3 ad=20.8n pd=0.504m as=20.8n ps=0.504m w=2e-06 l=2.8e-07
X8 VDDIO_t79 GP_t2 a_n7856_9000_t39 VDDIO_t78 pfet_03v3 ad=88n pd=2.176m as=52n ps=1.104m w=5e-06 l=2.8e-07
X9 VDDIO_t23 GP_t32 a_n7856_9000_t9 VDDIO_t22 pfet_03v3 ad=52n pd=1.104m as=52n ps=1.104m w=5e-06 l=2.8e-07
X10 a_n4804_11920_t1 PU_OK_t1 a_n4948_11920_t0 VSSIO_t52 nfet_03v3 ad=17.6n pd=0.576m as=17.6n ps=0.576m w=1e-06 l=2.8e-07
X11 a_n3172_11920_t0 a_n6172_11080_t2 a_n3172_11080_t1 VDDIO_t93 pfet_03v3 ad=35.2n pd=0.976m as=35.2n ps=0.976m w=2e-06 l=2.8e-07
X12 a_n7856_9000_t10 GP_t31 VDDIO_t25 VDDIO_t24 pfet_03v3 ad=52n pd=1.104m as=52n ps=1.104m w=5e-06 l=2.8e-07
X13 VSSIO_t5 GN_t18 a_n7856_9000_t63 VSSIO_t4 nfet_03v3 ad=20.8n pd=0.504m as=20.8n ps=0.504m w=2e-06 l=2.8e-07
X14 a_n7856_9000_t32 GP_t9 VDDIO_t67 VDDIO_t66 pfet_03v3 ad=52n pd=1.104m as=52n ps=1.104m w=5e-06 l=2.8e-07
X15 VSSIO_t70 a_n5372_11080_t3 a_n4804_11920_t0 VSSIO_t69 nfet_03v3 ad=17.6n pd=0.576m as=17.6n ps=0.576m w=1e-06 l=2.8e-07
X16 VSSIO_t13 GN_t16 a_n7856_9000_t65 VSSIO_t12 nfet_03v3 ad=20.8n pd=0.504m as=20.8n ps=0.504m w=2e-06 l=2.8e-07
X17 a_n3172_11920_t1 a_n6172_11080_t3 VSSIO_t219 VSSIO_t218 nfet_03v3 ad=17.6n pd=0.576m as=17.6n ps=0.576m w=1e-06 l=2.8e-07
X18 VSSIO_t136 VSSIO_t134 PAD_t14 VSSIO_t135 nfet_03v3 ad=20.8n pd=0.504m as=20.8n ps=0.504m w=2e-06 l=2.8e-07
X19 a_n7856_9000_t2 GP_t39 VDDIO_t9 VDDIO_t8 pfet_03v3 ad=52n pd=1.104m as=52n ps=1.104m w=5e-06 l=2.8e-07
X20 VSSIO_t181 VSSIO_t179 PAD_t34 VSSIO_t180 nfet_03v3 ad=20.8n pd=0.504m as=20.8n ps=0.504m w=2e-06 l=2.8e-07
X21 PAD_t1 VSSIO_t86 VSSIO_t88 VSSIO_t87 nfet_03v3 ad=20.8n pd=0.504m as=35.2n ps=0.976m w=2e-06 l=2.8e-07
X22 a_n7856_9000_t62 GN_t19 VSSIO_t21 VSSIO_t20 nfet_03v3 ad=20.8n pd=0.504m as=20.8n ps=0.504m w=2e-06 l=2.8e-07
X23 VDDIO_t73 GP_t8 a_n7856_9000_t33 VDDIO_t72 pfet_03v3 ad=52n pd=1.104m as=52n ps=1.104m w=5e-06 l=2.8e-07
X24 a_n972_11080_t1 a_n1772_11080_t2 VDDIO_t107 VDDIO_t106 pfet_03v3 ad=35.2n pd=0.976m as=35.2n ps=0.976m w=2e-06 l=2.8e-07
X25 PAD_t31 VSSIO_t176 VSSIO_t178 VSSIO_t177 nfet_03v3 ad=20.8n pd=0.504m as=20.8n ps=0.504m w=2e-06 l=2.8e-07
X26 a_n7856_9000_t70 GN_t11 VSSIO_t64 VSSIO_t63 nfet_03v3 ad=20.8n pd=0.504m as=20.8n ps=0.504m w=2e-06 l=2.8e-07
X27 VDDIO_t5 GP_t38 a_n7856_9000_t3 VDDIO_t4 pfet_03v3 ad=52n pd=1.104m as=52n ps=1.104m w=5e-06 l=2.8e-07
X28 VSSIO_t205 VSSIO_t203 PAD_t40 VSSIO_t204 nfet_03v3 ad=35.2n pd=0.976m as=20.8n ps=0.504m w=2e-06 l=2.8e-07
X29 a_n972_11080_t0 a_n1772_11080_t3 VSSIO_t81 VSSIO_t80 nfet_03v3 ad=17.6n pd=0.576m as=17.6n ps=0.576m w=1e-06 l=2.8e-07
X30 VSSIO_t225 GN_t12 a_n7856_9000_t69 VSSIO_t224 nfet_03v3 ad=20.8n pd=0.504m as=20.8n ps=0.504m w=2e-06 l=2.8e-07
X31 a_n7856_9000_t26 GP_t15 VDDIO_t57 VDDIO_t56 pfet_03v3 ad=52n pd=1.104m as=52n ps=1.104m w=5e-06 l=2.8e-07
X32 PAD_t37 VSSIO_t197 VSSIO_t199 VSSIO_t198 nfet_03v3 ad=20.8n pd=0.504m as=20.8n ps=0.504m w=2e-06 l=2.8e-07
X33 a_n7856_9000_t24 GP_t17 VDDIO_t53 VDDIO_t52 pfet_03v3 ad=52n pd=1.104m as=52n ps=1.104m w=5e-06 l=2.8e-07
X34 VSSIO_t211 GN_t10 a_n7856_9000_t71 VSSIO_t210 nfet_03v3 ad=20.8n pd=0.504m as=20.8n ps=0.504m w=2e-06 l=2.8e-07
D0 VSSIO_t232 VDDIO_t98 diode_pd2nw_03v3 pj=4e-05 area=1e-10
X35 VSSIO_t1 GN_t38 a_n7856_9000_t43 VSSIO_t0 nfet_03v3 ad=20.8n pd=0.504m as=20.8n ps=0.504m w=2e-06 l=2.8e-07
D1 VSSIO_t206 PAD_t44 diode_nd2ps_03v3 pj=3.2e-05 area=6.4e-11
X36 VSSIO_t142 VSSIO_t140 PAD_t16 VSSIO_t141 nfet_03v3 ad=20.8n pd=0.504m as=20.8n ps=0.504m w=2e-06 l=2.8e-07
X37 a_n7856_9000_t48 GN_t33 VSSIO_t3 VSSIO_t2 nfet_03v3 ad=20.8n pd=0.504m as=20.8n ps=0.504m w=2e-06 l=2.8e-07
X38 a_n7856_9000_t42 GN_t39 VSSIO_t17 VSSIO_t16 nfet_03v3 ad=20.8n pd=0.504m as=20.8n ps=0.504m w=2e-06 l=2.8e-07
X39 VDDIO_t49 GP_t22 a_n7856_9000_t19 VDDIO_t48 pfet_03v3 ad=52n pd=1.104m as=52n ps=1.104m w=5e-06 l=2.8e-07
X40 a_n7856_9000_t76 GN_t5 VSSIO_t217 VSSIO_t216 nfet_03v3 ad=20.8n pd=0.504m as=20.8n ps=0.504m w=2e-06 l=2.8e-07
X41 VDDIO_t39 GP_t24 a_n7856_9000_t17 VDDIO_t38 pfet_03v3 ad=52n pd=1.104m as=52n ps=1.104m w=5e-06 l=2.8e-07
X42 PAD_t29 VSSIO_t167 VSSIO_t169 VSSIO_t168 nfet_03v3 ad=20.8n pd=0.504m as=20.8n ps=0.504m w=2e-06 l=2.8e-07
X43 a_n7856_9000_t78 GN_t3 VSSIO_t83 VSSIO_t82 nfet_03v3 ad=20.8n pd=0.504m as=20.8n ps=0.504m w=2e-06 l=2.8e-07
X44 VSSIO_t19 GN_t34 a_n7856_9000_t47 VSSIO_t18 nfet_03v3 ad=20.8n pd=0.504m as=20.8n ps=0.504m w=2e-06 l=2.8e-07
X45 a_n7856_9000_t20 GP_t21 VDDIO_t47 VDDIO_t46 pfet_03v3 ad=52n pd=1.104m as=52n ps=1.104m w=5e-06 l=2.8e-07
X46 VSSIO_t163 VSSIO_t161 PAD_t26 VSSIO_t162 nfet_03v3 ad=20.8n pd=0.504m as=20.8n ps=0.504m w=2e-06 l=2.8e-07
X47 VSSIO_t39 GN_t4 a_n7856_9000_t77 VSSIO_t38 nfet_03v3 ad=20.8n pd=0.504m as=20.8n ps=0.504m w=2e-06 l=2.8e-07
X48 VSSIO_t56 GN_t26 a_n7856_9000_t55 VSSIO_t55 nfet_03v3 ad=20.8n pd=0.504m as=20.8n ps=0.504m w=2e-06 l=2.8e-07
X49 a_n7856_9000_t18 GP_t23 VDDIO_t43 VDDIO_t42 pfet_03v3 ad=52n pd=1.104m as=52n ps=1.104m w=5e-06 l=2.8e-07
X50 IN_t0 PAD_t42 VSSIO_t79 VSSIO_t78 nfet_03v3 ad=35.2n pd=0.976m as=35.2n ps=0.976m w=2e-06 l=2.8e-07
X51 a_n7856_9000_t12 GP_t29 VDDIO_t21 VDDIO_t20 pfet_03v3 ad=52n pd=1.104m as=52n ps=1.104m w=5e-06 l=2.8e-07
X52 PAD_t35 VSSIO_t188 VSSIO_t190 VSSIO_t189 nfet_03v3 ad=20.8n pd=0.504m as=20.8n ps=0.504m w=2e-06 l=2.8e-07
X53 VSSIO_t124 VSSIO_t122 PAD_t12 VSSIO_t123 nfet_03v3 ad=20.8n pd=0.504m as=20.8n ps=0.504m w=2e-06 l=2.8e-07
X54 a_n7856_9000_t54 GN_t27 VSSIO_t49 VSSIO_t48 nfet_03v3 ad=20.8n pd=0.504m as=20.8n ps=0.504m w=2e-06 l=2.8e-07
X55 VSSIO_t184 VSSIO_t182 PAD_t32 VSSIO_t183 nfet_03v3 ad=20.8n pd=0.504m as=20.8n ps=0.504m w=2e-06 l=2.8e-07
X56 VDDIO_t27 GP_t28 a_n7856_9000_t13 VDDIO_t26 pfet_03v3 ad=52n pd=1.104m as=52n ps=1.104m w=5e-06 l=2.8e-07
X57 VDDIO_t19 GP_t30 a_n7856_9000_t11 VDDIO_t18 pfet_03v3 ad=52n pd=1.104m as=52n ps=1.104m w=5e-06 l=2.8e-07
X58 PAD_t9 VSSIO_t113 VSSIO_t115 VSSIO_t114 nfet_03v3 ad=20.8n pd=0.504m as=20.8n ps=0.504m w=2e-06 l=2.8e-07
X59 VSSIO_t202 VSSIO_t200 PAD_t38 VSSIO_t201 nfet_03v3 ad=20.8n pd=0.504m as=20.8n ps=0.504m w=2e-06 l=2.8e-07
X60 VSSIO_t51 GN_t20 a_n7856_9000_t61 VSSIO_t50 nfet_03v3 ad=20.8n pd=0.504m as=20.8n ps=0.504m w=2e-06 l=2.8e-07
X61 a_n7856_9000_t34 GP_t7 VDDIO_t71 VDDIO_t70 pfet_03v3 ad=52n pd=1.104m as=52n ps=1.104m w=5e-06 l=2.8e-07
X62 a_n1772_11080_t0 a_n3172_11920_t3 VDDIO_t92 VDDIO_t91 pfet_03v3 ad=35.2n pd=0.976m as=35.2n ps=0.976m w=2e-06 l=2.8e-07
X63 a_n7856_9000_t6 GP_t35 VDDIO_t13 VDDIO_t12 pfet_03v3 ad=52n pd=1.104m as=52n ps=1.104m w=5e-06 l=2.8e-07
X64 a_n7856_9000_t4 GP_t37 VDDIO_t11 VDDIO_t10 pfet_03v3 ad=52n pd=1.104m as=52n ps=1.104m w=5e-06 l=2.8e-07
X65 a_2028_11080_t0 a_628_11920_t3 VDDIO_t95 VDDIO_t94 pfet_03v3 ad=35.2n pd=0.976m as=35.2n ps=0.976m w=2e-06 l=2.8e-07
X66 VDDIO_t69 GP_t6 a_n7856_9000_t35 VDDIO_t68 pfet_03v3 ad=52n pd=1.104m as=52n ps=1.104m w=5e-06 l=2.8e-07
X67 a_n1772_11080_t1 a_n3172_11920_t4 VSSIO_t231 VSSIO_t230 nfet_03v3 ad=17.6n pd=0.576m as=17.6n ps=0.576m w=1e-06 l=2.8e-07
X68 PAD_t21 VSSIO_t149 VSSIO_t151 VSSIO_t150 nfet_03v3 ad=20.8n pd=0.504m as=35.2n ps=0.976m w=2e-06 l=2.8e-07
X69 a_n7856_9000_t68 GN_t13 VSSIO_t43 VSSIO_t42 nfet_03v3 ad=20.8n pd=0.504m as=20.8n ps=0.504m w=2e-06 l=2.8e-07
X70 VDDIO_t7 GP_t36 a_n7856_9000_t5 VDDIO_t6 pfet_03v3 ad=52n pd=1.104m as=52n ps=1.104m w=5e-06 l=2.8e-07
X71 VDDIO_t61 GP_t14 a_n7856_9000_t27 VDDIO_t60 pfet_03v3 ad=52n pd=1.104m as=52n ps=1.104m w=5e-06 l=2.8e-07
X72 a_2028_11080_t1 a_628_11920_t4 VSSIO_t209 VSSIO_t208 nfet_03v3 ad=17.6n pd=0.576m as=17.6n ps=0.576m w=1e-06 l=2.8e-07
X73 a_n7856_9000_t40 GN_t41 VSSIO_t7 VSSIO_t6 nfet_03v3 ad=20.8n pd=0.504m as=35.2n ps=0.976m w=2e-06 l=2.8e-07
X74 PAD_t7 VSSIO_t107 VSSIO_t109 VSSIO_t108 nfet_03v3 ad=20.8n pd=0.504m as=20.8n ps=0.504m w=2e-06 l=2.8e-07
X75 PAD_t27 VSSIO_t164 VSSIO_t166 VSSIO_t165 nfet_03v3 ad=20.8n pd=0.504m as=20.8n ps=0.504m w=2e-06 l=2.8e-07
X76 VSSIO_t35 GN_t14 a_n7856_9000_t67 VSSIO_t34 nfet_03v3 ad=20.8n pd=0.504m as=20.8n ps=0.504m w=2e-06 l=2.8e-07
X77 a_n7856_9000_t28 GP_t13 VDDIO_t59 VDDIO_t58 pfet_03v3 ad=52n pd=1.104m as=52n ps=1.104m w=5e-06 l=2.8e-07
X78 PAD_t19 VSSIO_t143 VSSIO_t145 VSSIO_t144 nfet_03v3 ad=20.8n pd=0.504m as=20.8n ps=0.504m w=2e-06 l=2.8e-07
X79 VSSIO_t106 VSSIO_t104 PAD_t4 VSSIO_t105 nfet_03v3 ad=20.8n pd=0.504m as=20.8n ps=0.504m w=2e-06 l=2.8e-07
X80 a_n4948_11920_t1 PU_OK_t0 VDDIO_t105 VDDIO_t104 pfet_03v3 ad=35.2n pd=0.976m as=35.2n ps=0.976m w=2e-06 l=2.8e-07
X81 a_n7856_9000_t0 GP_t41 VDDIO_t1 VDDIO_t0 pfet_03v3 ad=52n pd=1.104m as=88n ps=2.176m w=5e-06 l=2.8e-07
X82 VSSIO_t23 GN_t40 a_n7856_9000_t41 VSSIO_t22 nfet_03v3 ad=20.8n pd=0.504m as=20.8n ps=0.504m w=2e-06 l=2.8e-07
X83 VSSIO_t157 VSSIO_t155 PAD_t24 VSSIO_t156 nfet_03v3 ad=20.8n pd=0.504m as=20.8n ps=0.504m w=2e-06 l=2.8e-07
X84 VSSIO_t227 GN_t6 a_n7856_9000_t75 VSSIO_t226 nfet_03v3 ad=20.8n pd=0.504m as=20.8n ps=0.504m w=2e-06 l=2.8e-07
X85 PAD_t13 VSSIO_t128 VSSIO_t130 VSSIO_t129 nfet_03v3 ad=20.8n pd=0.504m as=20.8n ps=0.504m w=2e-06 l=2.8e-07
R_SERIES a_n7856_9000_t80 PAD_t0 22.272727
X87 a_n7856_9000_t46 GN_t35 VSSIO_t72 VSSIO_t71 nfet_03v3 ad=20.8n pd=0.504m as=20.8n ps=0.504m w=2e-06 l=2.8e-07
X88 a_n4948_11920_t2 a_n5372_11080_t2 VDDIO_t109 VDDIO_t108 pfet_03v3 ad=35.2n pd=0.976m as=35.2n ps=0.976m w=2e-06 l=2.8e-07
X89 PAD_t33 VSSIO_t185 VSSIO_t187 VSSIO_t186 nfet_03v3 ad=20.8n pd=0.504m as=20.8n ps=0.504m w=2e-06 l=2.8e-07
X90 VDDIO_t45 GP_t20 a_n7856_9000_t21 VDDIO_t44 pfet_03v3 ad=52n pd=1.104m as=52n ps=1.104m w=5e-06 l=2.8e-07
X91 VSSIO_t121 VSSIO_t119 PAD_t10 VSSIO_t120 nfet_03v3 ad=20.8n pd=0.504m as=20.8n ps=0.504m w=2e-06 l=2.8e-07
X92 a_n7856_9000_t74 GN_t7 VSSIO_t37 VSSIO_t36 nfet_03v3 ad=20.8n pd=0.504m as=20.8n ps=0.504m w=2e-06 l=2.8e-07
X93 VSSIO_t175 VSSIO_t173 PAD_t30 VSSIO_t174 nfet_03v3 ad=20.8n pd=0.504m as=20.8n ps=0.504m w=2e-06 l=2.8e-07
X94 GN_t1 a_2028_11080_t2 VDDIO_t97 VDDIO_t96 pfet_03v3 ad=35.2n pd=0.976m as=35.2n ps=0.976m w=2e-06 l=2.8e-07
X95 VSSIO_t45 GN_t30 a_n7856_9000_t51 VSSIO_t44 nfet_03v3 ad=20.8n pd=0.504m as=20.8n ps=0.504m w=2e-06 l=2.8e-07
X96 VSSIO_t213 GN_t28 a_n7856_9000_t53 VSSIO_t212 nfet_03v3 ad=20.8n pd=0.504m as=20.8n ps=0.504m w=2e-06 l=2.8e-07
X97 GN_t0 a_2028_11080_t3 VSSIO_t66 VSSIO_t65 nfet_03v3 ad=17.6n pd=0.576m as=17.6n ps=0.576m w=1e-06 l=2.8e-07
X98 a_n7856_9000_t14 GP_t27 VDDIO_t29 VDDIO_t28 pfet_03v3 ad=52n pd=1.104m as=52n ps=1.104m w=5e-06 l=2.8e-07
X99 VSSIO_t94 VSSIO_t92 PAD_t22 VSSIO_t93 nfet_03v3 ad=20.8n pd=0.504m as=20.8n ps=0.504m w=2e-06 l=2.8e-07
X100 a_n7856_9000_t52 GN_t29 VSSIO_t47 VSSIO_t46 nfet_03v3 ad=20.8n pd=0.504m as=20.8n ps=0.504m w=2e-06 l=2.8e-07
X101 a_n7856_9000_t58 GN_t23 VSSIO_t223 VSSIO_t222 nfet_03v3 ad=20.8n pd=0.504m as=20.8n ps=0.504m w=2e-06 l=2.8e-07
X102 a_n5372_11080_t1 OE_N_t0 VDDIO_t86 VDDIO_t85 pfet_03v3 ad=35.2n pd=0.976m as=35.2n ps=0.976m w=2e-06 l=2.8e-07
X103 a_628_11920_t0 OUT_t0 a_628_11080_t1 VDDIO_t84 pfet_03v3 ad=35.2n pd=0.976m as=35.2n ps=0.976m w=2e-06 l=2.8e-07
X104 VDDIO_t31 GP_t26 a_n7856_9000_t15 VDDIO_t30 pfet_03v3 ad=52n pd=1.104m as=52n ps=1.104m w=5e-06 l=2.8e-07
X105 VDDIO_t75 GP_t4 a_n7856_9000_t37 VDDIO_t74 pfet_03v3 ad=52n pd=1.104m as=52n ps=1.104m w=5e-06 l=2.8e-07
X106 a_n7856_9000_t60 GN_t21 VSSIO_t215 VSSIO_t214 nfet_03v3 ad=20.8n pd=0.504m as=20.8n ps=0.504m w=2e-06 l=2.8e-07
X107 VDDIO_t15 GP_t34 a_n7856_9000_t7 VDDIO_t14 pfet_03v3 ad=52n pd=1.104m as=52n ps=1.104m w=5e-06 l=2.8e-07
X108 VSSIO_t172 VSSIO_t170 PAD_t28 VSSIO_t171 nfet_03v3 ad=20.8n pd=0.504m as=20.8n ps=0.504m w=2e-06 l=2.8e-07
D2 VSSIO_t76 PAD_t43 diode_nd2ps_03v3 pj=3.2e-05 area=6.4e-11
X109 VSSIO_t41 GN_t24 a_n7856_9000_t57 VSSIO_t40 nfet_03v3 ad=20.8n pd=0.504m as=20.8n ps=0.504m w=2e-06 l=2.8e-07
X110 a_n5372_11080_t0 OE_N_t1 VSSIO_t85 VSSIO_t84 nfet_03v3 ad=17.6n pd=0.576m as=17.6n ps=0.576m w=1e-06 l=2.8e-07
X111 a_628_11920_t1 OUT_t2 VSSIO_t68 VSSIO_t67 nfet_03v3 ad=17.6n pd=0.576m as=17.6n ps=0.576m w=1e-06 l=2.8e-07
X112 a_n7856_9000_t38 GP_t3 VDDIO_t77 VDDIO_t76 pfet_03v3 ad=52n pd=1.104m as=52n ps=1.104m w=5e-06 l=2.8e-07
X113 VSSIO_t148 VSSIO_t146 PAD_t20 VSSIO_t147 nfet_03v3 ad=35.2n pd=0.976m as=20.8n ps=0.504m w=2e-06 l=2.8e-07
X114 PAD_t5 VSSIO_t98 VSSIO_t100 VSSIO_t99 nfet_03v3 ad=20.8n pd=0.504m as=20.8n ps=0.504m w=2e-06 l=2.8e-07
X115 VSSIO_t62 GN_t22 a_n7856_9000_t59 VSSIO_t61 nfet_03v3 ad=20.8n pd=0.504m as=20.8n ps=0.504m w=2e-06 l=2.8e-07
X116 a_n7856_9000_t36 GP_t5 VDDIO_t33 VDDIO_t32 pfet_03v3 ad=52n pd=1.104m as=52n ps=1.104m w=5e-06 l=2.8e-07
X117 PAD_t25 VSSIO_t158 VSSIO_t160 VSSIO_t159 nfet_03v3 ad=20.8n pd=0.504m as=20.8n ps=0.504m w=2e-06 l=2.8e-07
X118 a_n7856_9000_t8 GP_t33 VDDIO_t17 VDDIO_t16 pfet_03v3 ad=52n pd=1.104m as=52n ps=1.104m w=5e-06 l=2.8e-07
X119 PAD_t17 VSSIO_t131 VSSIO_t133 VSSIO_t132 nfet_03v3 ad=20.8n pd=0.504m as=20.8n ps=0.504m w=2e-06 l=2.8e-07
X120 VSSIO_t91 VSSIO_t89 PAD_t2 VSSIO_t90 nfet_03v3 ad=20.8n pd=0.504m as=20.8n ps=0.504m w=2e-06 l=2.8e-07
X121 PAD_t11 VSSIO_t116 VSSIO_t118 VSSIO_t117 nfet_03v3 ad=20.8n pd=0.504m as=20.8n ps=0.504m w=2e-06 l=2.8e-07
X122 a_n7856_9000_t64 GN_t17 VSSIO_t58 VSSIO_t57 nfet_03v3 ad=20.8n pd=0.504m as=20.8n ps=0.504m w=2e-06 l=2.8e-07
X123 VDDIO_t65 GP_t10 a_n7856_9000_t31 VDDIO_t64 pfet_03v3 ad=52n pd=1.104m as=52n ps=1.104m w=5e-06 l=2.8e-07
X124 a_n7856_9000_t66 GN_t15 VSSIO_t29 VSSIO_t28 nfet_03v3 ad=20.8n pd=0.504m as=20.8n ps=0.504m w=2e-06 l=2.8e-07
X125 VDDIO_t37 GP_t12 a_n7856_9000_t29 VDDIO_t36 pfet_03v3 ad=52n pd=1.104m as=52n ps=1.104m w=5e-06 l=2.8e-07
X126 VDDIO_t3 GP_t40 a_n7856_9000_t1 VDDIO_t2 pfet_03v3 ad=52n pd=1.104m as=52n ps=1.104m w=5e-06 l=2.8e-07
X127 VSSIO_t112 VSSIO_t110 PAD_t8 VSSIO_t111 nfet_03v3 ad=20.8n pd=0.504m as=20.8n ps=0.504m w=2e-06 l=2.8e-07
X128 IN_t1 PAD_t41 VDDIO_t103 VDDIO_t102 pfet_03v3 ad=70.4n pd=1.776m as=70.4n ps=1.776m w=4e-06 l=2.8e-07
X129 a_n7856_9000_t30 GP_t11 VDDIO_t63 VDDIO_t62 pfet_03v3 ad=52n pd=1.104m as=52n ps=1.104m w=5e-06 l=2.8e-07
X130 a_n6172_11080_t1 OUT_t1 VDDIO_t83 VDDIO_t82 pfet_03v3 ad=35.2n pd=0.976m as=35.2n ps=0.976m w=2e-06 l=2.8e-07
X131 a_n7856_9000_t22 GP_t19 VDDIO_t35 VDDIO_t34 pfet_03v3 ad=52n pd=1.104m as=52n ps=1.104m w=5e-06 l=2.8e-07
X132 VSSIO_t31 GN_t8 a_n7856_9000_t73 VSSIO_t30 nfet_03v3 ad=20.8n pd=0.504m as=20.8n ps=0.504m w=2e-06 l=2.8e-07
X133 VSSIO_t25 GN_t36 a_n7856_9000_t45 VSSIO_t24 nfet_03v3 ad=20.8n pd=0.504m as=20.8n ps=0.504m w=2e-06 l=2.8e-07
X134 a_n6172_11080_t0 OUT_t3 VSSIO_t54 VSSIO_t53 nfet_03v3 ad=17.6n pd=0.576m as=17.6n ps=0.576m w=1e-06 l=2.8e-07
D3 PAD_t45 VDDIO_t100 diode_pd2nw_03v3 pj=3.2e-05 area=6.4e-11
X135 GP_t0 a_n972_11080_t2 VDDIO_t88 VDDIO_t87 pfet_03v3 ad=35.2n pd=0.976m as=35.2n ps=0.976m w=2e-06 l=2.8e-07
X136 VDDIO_t55 GP_t16 a_n7856_9000_t25 VDDIO_t54 pfet_03v3 ad=52n pd=1.104m as=52n ps=1.104m w=5e-06 l=2.8e-07
X137 a_628_11080_t0 a_n4948_11920_t3 VDDIO_t81 VDDIO_t80 pfet_03v3 ad=35.2n pd=0.976m as=35.2n ps=0.976m w=2e-06 l=2.8e-07
X138 VDDIO_t51 GP_t18 a_n7856_9000_t23 VDDIO_t50 pfet_03v3 ad=52n pd=1.104m as=52n ps=1.104m w=5e-06 l=2.8e-07
X139 a_n7856_9000_t72 GN_t9 VSSIO_t15 VSSIO_t14 nfet_03v3 ad=20.8n pd=0.504m as=20.8n ps=0.504m w=2e-06 l=2.8e-07
X140 a_n7856_9000_t50 GN_t31 VSSIO_t27 VSSIO_t26 nfet_03v3 ad=20.8n pd=0.504m as=20.8n ps=0.504m w=2e-06 l=2.8e-07
X141 a_n3172_11080_t0 a_n4948_11920_t4 VDDIO_t90 VDDIO_t89 pfet_03v3 ad=35.2n pd=0.976m as=35.2n ps=0.976m w=2e-06 l=2.8e-07
X142 a_n7856_9000_t44 GN_t37 VSSIO_t9 VSSIO_t8 nfet_03v3 ad=20.8n pd=0.504m as=20.8n ps=0.504m w=2e-06 l=2.8e-07
X143 GP_t1 a_n972_11080_t3 VSSIO_t229 VSSIO_t228 nfet_03v3 ad=17.6n pd=0.576m as=17.6n ps=0.576m w=1e-06 l=2.8e-07
X144 a_628_11920_t2 a_n4948_11920_t5 VSSIO_t60 VSSIO_t59 nfet_03v3 ad=17.6n pd=0.576m as=17.6n ps=0.576m w=1e-06 l=2.8e-07
X145 PAD_t39 VSSIO_t194 VSSIO_t196 VSSIO_t195 nfet_03v3 ad=20.8n pd=0.504m as=20.8n ps=0.504m w=2e-06 l=2.8e-07
X146 VSSIO_t97 VSSIO_t95 PAD_t6 VSSIO_t96 nfet_03v3 ad=20.8n pd=0.504m as=20.8n ps=0.504m w=2e-06 l=2.8e-07
X147 VSSIO_t11 GN_t32 a_n7856_9000_t49 VSSIO_t10 nfet_03v3 ad=20.8n pd=0.504m as=20.8n ps=0.504m w=2e-06 l=2.8e-07
X148 a_n3172_11920_t2 a_n4948_11920_t6 VSSIO_t221 VSSIO_t220 nfet_03v3 ad=17.6n pd=0.576m as=17.6n ps=0.576m w=1e-06 l=2.8e-07
R0 VSSIO_n198 VSSIO_n23 23902.5
R1 VSSIO_n68 VSSIO_n66 14754
R2 VSSIO_n122 VSSIO_n29 14754
R3 VSSIO_n124 VSSIO_n27 14754
R4 VSSIO_n156 VSSIO_n23 7184.56
R5 VSSIO_n100 VSSIO_n65 6500
R6 VSSIO_n121 VSSIO_n30 6500
R7 VSSIO_n123 VSSIO_n28 6500
R8 VSSIO_n126 VSSIO_n25 6075.16
R9 VSSIO_n119 VSSIO_n32 6075.16
R10 VSSIO_n103 VSSIO_n64 6075.16
R11 VSSIO_n71 VSSIO_n69 6075.16
R12 VSSIO_n125 VSSIO_n26 6075.16
R13 VSSIO_n120 VSSIO_n31 5939.47
R14 VSSIO_n127 VSSIO_n126 5843.71
R15 VSSIO_n197 VSSIO_n127 4905.69
R16 VSSIO_t76 VSSIO_n195 4286.02
R17 VSSIO_t65 VSSIO_n63 2878.83
R18 VSSIO_n126 VSSIO_n125 2863.44
R19 VSSIO_n121 VSSIO_n120 2747.36
R20 VSSIO_n125 VSSIO_n124 2541.3
R21 VSSIO_n124 VSSIO_n123 2505.51
R22 VSSIO_n123 VSSIO_n122 2505.51
R23 VSSIO_n122 VSSIO_n121 2505.51
R24 VSSIO_n198 VSSIO_n197 2054.5
R25 VSSIO_n196 VSSIO_t76 1721.23
R26 VSSIO_n168 VSSIO_t204 1698.67
R27 VSSIO_n127 VSSIO_n24 1499.81
R28 VSSIO_n120 VSSIO_n119 1323.82
R29 VSSIO_n198 VSSIO_t78 1089.29
R30 VSSIO_n119 VSSIO_n118 839.062
R31 VSSIO_n199 VSSIO_n198 822.636
R32 VSSIO_n200 VSSIO_n199 700.774
R33 VSSIO_n196 VSSIO_t206 439.973
R34 VSSIO_n25 VSSIO_t53 374.108
R35 VSSIO_t84 VSSIO_n26 374.108
R36 VSSIO_t80 VSSIO_n32 374.108
R37 VSSIO_t228 VSSIO_n71 374.108
R38 VSSIO_n103 VSSIO_t208 374.108
R39 VSSIO_t230 VSSIO_n31 373.075
R40 VSSIO_n82 VSSIO_n28 372.002
R41 VSSIO_t218 VSSIO_n30 363.57
R42 VSSIO_n100 VSSIO_t67 363.57
R43 VSSIO_n118 VSSIO_t6 350
R44 VSSIO_n84 VSSIO_n27 287.695
R45 VSSIO_t220 VSSIO_n29 279.264
R46 VSSIO_t59 VSSIO_n66 279.264
R47 VSSIO_t22 VSSIO_t16 250
R48 VSSIO_t16 VSSIO_t0 250
R49 VSSIO_t0 VSSIO_t8 250
R50 VSSIO_t24 VSSIO_t71 250
R51 VSSIO_t71 VSSIO_t18 250
R52 VSSIO_t18 VSSIO_t2 250
R53 VSSIO_t2 VSSIO_t10 250
R54 VSSIO_t26 VSSIO_t44 250
R55 VSSIO_t44 VSSIO_t46 250
R56 VSSIO_t46 VSSIO_t212 250
R57 VSSIO_t48 VSSIO_t55 250
R58 VSSIO_t55 VSSIO_t32 250
R59 VSSIO_t32 VSSIO_t40 250
R60 VSSIO_t40 VSSIO_t222 250
R61 VSSIO_t222 VSSIO_t61 250
R62 VSSIO_t61 VSSIO_t214 250
R63 VSSIO_t214 VSSIO_t50 250
R64 VSSIO_t50 VSSIO_t20 250
R65 VSSIO_t57 VSSIO_t4 250
R66 VSSIO_t12 VSSIO_t57 250
R67 VSSIO_t28 VSSIO_t12 250
R68 VSSIO_t34 VSSIO_t28 250
R69 VSSIO_t42 VSSIO_t34 250
R70 VSSIO_t224 VSSIO_t42 250
R71 VSSIO_t63 VSSIO_t224 250
R72 VSSIO_t210 VSSIO_t63 250
R73 VSSIO_t14 VSSIO_t210 250
R74 VSSIO_t30 VSSIO_t14 250
R75 VSSIO_t36 VSSIO_t30 250
R76 VSSIO_t226 VSSIO_t36 250
R77 VSSIO_t216 VSSIO_t226 250
R78 VSSIO_t38 VSSIO_t82 250
R79 VSSIO_t82 VSSIO_t73 250
R80 VSSIO_t212 VSSIO_n64 248.439
R81 VSSIO_t53 VSSIO_n24 236.058
R82 VSSIO_n85 VSSIO_t84 236.058
R83 VSSIO_n84 VSSIO_t52 236.058
R84 VSSIO_n82 VSSIO_t69 236.058
R85 VSSIO_n80 VSSIO_t220 236.058
R86 VSSIO_n78 VSSIO_t218 236.058
R87 VSSIO_n76 VSSIO_t230 236.058
R88 VSSIO_n74 VSSIO_t80 236.058
R89 VSSIO_n72 VSSIO_t228 236.058
R90 VSSIO_n70 VSSIO_t59 236.058
R91 VSSIO_t67 VSSIO_n99 236.058
R92 VSSIO_t208 VSSIO_n102 236.058
R93 VSSIO_n104 VSSIO_t65 236.058
R94 VSSIO_n65 VSSIO_t26 235.939
R95 VSSIO_n85 VSSIO_n25 232.897
R96 VSSIO_n72 VSSIO_n32 232.897
R97 VSSIO_n71 VSSIO_n70 232.897
R98 VSSIO_n104 VSSIO_n103 232.897
R99 VSSIO_n74 VSSIO_n31 231.821
R100 VSSIO_t52 VSSIO_n26 224.465
R101 VSSIO_n199 VSSIO_t20 223.439
R102 VSSIO_n80 VSSIO_n28 222.357
R103 VSSIO_n76 VSSIO_n30 222.357
R104 VSSIO_n102 VSSIO_n100 222.357
R105 VSSIO_n63 VSSIO_t216 195.312
R106 VSSIO_n69 VSSIO_t22 189.062
R107 VSSIO_t8 VSSIO_n68 170.312
R108 VSSIO_n156 VSSIO_t147 170.024
R109 VSSIO_n78 VSSIO_n29 138.052
R110 VSSIO_n99 VSSIO_n66 138.052
R111 VSSIO_t69 VSSIO_n27 129.621
R112 VSSIO_n157 VSSIO_n156 128.917
R113 VSSIO_n157 VSSIO_t150 121.334
R114 VSSIO_n168 VSSIO_t78 121.334
R115 VSSIO_n200 VSSIO_t75 101.365
R116 VSSIO_t90 VSSIO_t87 97.8552
R117 VSSIO_t102 VSSIO_t90 97.8552
R118 VSSIO_t105 VSSIO_t102 97.8552
R119 VSSIO_t99 VSSIO_t105 97.8552
R120 VSSIO_t96 VSSIO_t99 97.8552
R121 VSSIO_t108 VSSIO_t96 97.8552
R122 VSSIO_t111 VSSIO_t108 97.8552
R123 VSSIO_t114 VSSIO_t111 97.8552
R124 VSSIO_t120 VSSIO_t114 97.8552
R125 VSSIO_t117 VSSIO_t120 97.8552
R126 VSSIO_t123 VSSIO_t117 97.8552
R127 VSSIO_t129 VSSIO_t123 97.8552
R128 VSSIO_t135 VSSIO_t129 97.8552
R129 VSSIO_t138 VSSIO_t135 97.8552
R130 VSSIO_t141 VSSIO_t138 97.8552
R131 VSSIO_t132 VSSIO_t141 97.8552
R132 VSSIO_t126 VSSIO_t132 97.8552
R133 VSSIO_t144 VSSIO_t126 97.8552
R134 VSSIO_t147 VSSIO_t144 97.8552
R135 VSSIO_t150 VSSIO_t93 86.6672
R136 VSSIO_t93 VSSIO_t153 86.6672
R137 VSSIO_t153 VSSIO_t156 86.6672
R138 VSSIO_t156 VSSIO_t159 86.6672
R139 VSSIO_t159 VSSIO_t162 86.6672
R140 VSSIO_t162 VSSIO_t165 86.6672
R141 VSSIO_t165 VSSIO_t171 86.6672
R142 VSSIO_t171 VSSIO_t168 86.6672
R143 VSSIO_t168 VSSIO_t174 86.6672
R144 VSSIO_t174 VSSIO_t177 86.6672
R145 VSSIO_t177 VSSIO_t183 86.6672
R146 VSSIO_t183 VSSIO_t186 86.6672
R147 VSSIO_t186 VSSIO_t180 86.6672
R148 VSSIO_t180 VSSIO_t189 86.6672
R149 VSSIO_t189 VSSIO_t192 86.6672
R150 VSSIO_t192 VSSIO_t198 86.6672
R151 VSSIO_t198 VSSIO_t201 86.6672
R152 VSSIO_t204 VSSIO_t195 86.6672
R153 VSSIO_n195 VSSIO_n194 79.9969
R154 VSSIO_n68 VSSIO_t24 79.688
R155 VSSIO_n69 VSSIO_t6 60.938
R156 VSSIO_n195 VSSIO_t87 59.9365
R157 VSSIO_t201 VSSIO_n23 55.7922
R158 VSSIO_n63 VSSIO_t38 54.688
R159 VSSIO_n137 VSSIO_t203 44.2698
R160 VSSIO_n2 VSSIO_t146 44.2698
R161 VSSIO_n21 VSSIO_n20 43.0442
R162 VSSIO_n182 VSSIO_n155 42.7878
R163 VSSIO_n197 VSSIO_n196 33.4523
R164 VSSIO_n202 VSSIO_n201 33.233
R165 VSSIO_n137 VSSIO_t194 32.5898
R166 VSSIO_n138 VSSIO_t200 32.5898
R167 VSSIO_n139 VSSIO_t197 32.5898
R168 VSSIO_n140 VSSIO_t191 32.5898
R169 VSSIO_n141 VSSIO_t188 32.5898
R170 VSSIO_n142 VSSIO_t179 32.5898
R171 VSSIO_n143 VSSIO_t185 32.5898
R172 VSSIO_n144 VSSIO_t182 32.5898
R173 VSSIO_n145 VSSIO_t176 32.5898
R174 VSSIO_n146 VSSIO_t173 32.5898
R175 VSSIO_n147 VSSIO_t167 32.5898
R176 VSSIO_n148 VSSIO_t170 32.5898
R177 VSSIO_n149 VSSIO_t164 32.5898
R178 VSSIO_n150 VSSIO_t161 32.5898
R179 VSSIO_n151 VSSIO_t158 32.5898
R180 VSSIO_n152 VSSIO_t155 32.5898
R181 VSSIO_n153 VSSIO_t152 32.5898
R182 VSSIO_n154 VSSIO_t92 32.5898
R183 VSSIO_n155 VSSIO_t149 32.5898
R184 VSSIO_n2 VSSIO_t143 32.5898
R185 VSSIO_n3 VSSIO_t125 32.5898
R186 VSSIO_n4 VSSIO_t131 32.5898
R187 VSSIO_n5 VSSIO_t140 32.5898
R188 VSSIO_n6 VSSIO_t137 32.5898
R189 VSSIO_n7 VSSIO_t134 32.5898
R190 VSSIO_n8 VSSIO_t128 32.5898
R191 VSSIO_n9 VSSIO_t122 32.5898
R192 VSSIO_n10 VSSIO_t116 32.5898
R193 VSSIO_n11 VSSIO_t119 32.5898
R194 VSSIO_n12 VSSIO_t113 32.5898
R195 VSSIO_n13 VSSIO_t110 32.5898
R196 VSSIO_n14 VSSIO_t107 32.5898
R197 VSSIO_n15 VSSIO_t95 32.5898
R198 VSSIO_n16 VSSIO_t98 32.5898
R199 VSSIO_n17 VSSIO_t104 32.5898
R200 VSSIO_n18 VSSIO_t101 32.5898
R201 VSSIO_n19 VSSIO_t89 32.5898
R202 VSSIO_n20 VSSIO_t86 32.5898
R203 VSSIO_t195 VSSIO_n23 30.8755
R204 VSSIO_n199 VSSIO_t4 26.563
R205 VSSIO_n107 VSSIO_n106 16.8827
R206 VSSIO_t10 VSSIO_n65 14.063
R207 VSSIO_n201 VSSIO_n22 13.595
R208 VSSIO_n201 VSSIO 12.4655
R209 VSSIO_n155 VSSIO_n154 11.6805
R210 VSSIO_n154 VSSIO_n153 11.6805
R211 VSSIO_n153 VSSIO_n152 11.6805
R212 VSSIO_n152 VSSIO_n151 11.6805
R213 VSSIO_n151 VSSIO_n150 11.6805
R214 VSSIO_n150 VSSIO_n149 11.6805
R215 VSSIO_n149 VSSIO_n148 11.6805
R216 VSSIO_n148 VSSIO_n147 11.6805
R217 VSSIO_n147 VSSIO_n146 11.6805
R218 VSSIO_n146 VSSIO_n145 11.6805
R219 VSSIO_n145 VSSIO_n144 11.6805
R220 VSSIO_n144 VSSIO_n143 11.6805
R221 VSSIO_n143 VSSIO_n142 11.6805
R222 VSSIO_n142 VSSIO_n141 11.6805
R223 VSSIO_n141 VSSIO_n140 11.6805
R224 VSSIO_n140 VSSIO_n139 11.6805
R225 VSSIO_n139 VSSIO_n138 11.6805
R226 VSSIO_n138 VSSIO_n137 11.6805
R227 VSSIO_n20 VSSIO_n19 11.6805
R228 VSSIO_n19 VSSIO_n18 11.6805
R229 VSSIO_n18 VSSIO_n17 11.6805
R230 VSSIO_n17 VSSIO_n16 11.6805
R231 VSSIO_n16 VSSIO_n15 11.6805
R232 VSSIO_n15 VSSIO_n14 11.6805
R233 VSSIO_n14 VSSIO_n13 11.6805
R234 VSSIO_n13 VSSIO_n12 11.6805
R235 VSSIO_n12 VSSIO_n11 11.6805
R236 VSSIO_n11 VSSIO_n10 11.6805
R237 VSSIO_n10 VSSIO_n9 11.6805
R238 VSSIO_n9 VSSIO_n8 11.6805
R239 VSSIO_n8 VSSIO_n7 11.6805
R240 VSSIO_n7 VSSIO_n6 11.6805
R241 VSSIO_n6 VSSIO_n5 11.6805
R242 VSSIO_n5 VSSIO_n4 11.6805
R243 VSSIO_n4 VSSIO_n3 11.6805
R244 VSSIO_n3 VSSIO_n2 11.6805
R245 VSSIO_n1 VSSIO 9.2345
R246 VSSIO_n0 VSSIO 8.0555
R247 VSSIO_n22 VSSIO_t74 7.3895
R248 VSSIO_n183 VSSIO_t148 7.277
R249 VSSIO_n171 VSSIO_t205 7.277
R250 VSSIO_n52 VSSIO_n51 6.53225
R251 VSSIO_n53 VSSIO_n50 6.53225
R252 VSSIO_n54 VSSIO_n49 6.53225
R253 VSSIO_n55 VSSIO_n48 6.53225
R254 VSSIO_n56 VSSIO_n47 6.53225
R255 VSSIO_n57 VSSIO_n46 6.53225
R256 VSSIO_n58 VSSIO_n45 6.53225
R257 VSSIO_n59 VSSIO_n44 6.53225
R258 VSSIO_n60 VSSIO_n43 6.53225
R259 VSSIO_n61 VSSIO_n42 6.53225
R260 VSSIO_n108 VSSIO_n41 6.53225
R261 VSSIO_n109 VSSIO_n40 6.53225
R262 VSSIO_n110 VSSIO_n39 6.53225
R263 VSSIO_n111 VSSIO_n38 6.53225
R264 VSSIO_n112 VSSIO_n37 6.53225
R265 VSSIO_n113 VSSIO_n36 6.53225
R266 VSSIO_n114 VSSIO_n35 6.53225
R267 VSSIO_n115 VSSIO_n34 6.53225
R268 VSSIO_n116 VSSIO_n33 6.53225
R269 VSSIO_n184 VSSIO_n136 6.458
R270 VSSIO_n185 VSSIO_n135 6.458
R271 VSSIO_n186 VSSIO_n134 6.458
R272 VSSIO_n187 VSSIO_n133 6.458
R273 VSSIO_n188 VSSIO_n132 6.458
R274 VSSIO_n189 VSSIO_n131 6.458
R275 VSSIO_n190 VSSIO_n130 6.458
R276 VSSIO_n191 VSSIO_n129 6.458
R277 VSSIO_n192 VSSIO_n128 6.458
R278 VSSIO_n172 VSSIO_n167 6.458
R279 VSSIO_n173 VSSIO_n166 6.458
R280 VSSIO_n174 VSSIO_n165 6.458
R281 VSSIO_n175 VSSIO_n164 6.458
R282 VSSIO_n176 VSSIO_n163 6.458
R283 VSSIO_n177 VSSIO_n162 6.458
R284 VSSIO_n178 VSSIO_n161 6.458
R285 VSSIO_n179 VSSIO_n160 6.458
R286 VSSIO_n180 VSSIO_n159 6.458
R287 VSSIO_n89 VSSIO_n84 5.66277
R288 VSSIO_n0 VSSIO 5.5355
R289 VSSIO_n87 VSSIO_n24 5.2005
R290 VSSIO_n86 VSSIO_n85 5.2005
R291 VSSIO_n83 VSSIO_n82 5.2005
R292 VSSIO_n81 VSSIO_n80 5.2005
R293 VSSIO_n79 VSSIO_n78 5.2005
R294 VSSIO_n77 VSSIO_n76 5.2005
R295 VSSIO_n75 VSSIO_n74 5.2005
R296 VSSIO_n73 VSSIO_n72 5.2005
R297 VSSIO_n70 VSSIO_n67 5.2005
R298 VSSIO_n99 VSSIO_n98 5.2005
R299 VSSIO_n102 VSSIO_n101 5.2005
R300 VSSIO_n105 VSSIO_n104 5.2005
R301 VSSIO_n170 VSSIO_n169 5.1222
R302 VSSIO_n117 VSSIO 4.9595
R303 VSSIO_n105 VSSIO_t66 4.901
R304 VSSIO_n101 VSSIO_t209 4.901
R305 VSSIO_n98 VSSIO_t68 4.901
R306 VSSIO_n67 VSSIO_t60 4.901
R307 VSSIO_n73 VSSIO_t229 4.901
R308 VSSIO_n75 VSSIO_t81 4.901
R309 VSSIO_n77 VSSIO_t231 4.901
R310 VSSIO_n79 VSSIO_t219 4.901
R311 VSSIO_n81 VSSIO_t221 4.901
R312 VSSIO_n83 VSSIO_t70 4.901
R313 VSSIO_n86 VSSIO_t85 4.901
R314 VSSIO_n87 VSSIO_t54 4.901
R315 VSSIO_n194 VSSIO_n193 4.883
R316 VSSIO_n181 VSSIO_n158 4.883
R317 VSSIO_n171 VSSIO_n170 3.61654
R318 VSSIO_n169 VSSIO_n168 2.93626
R319 VSSIO_n158 VSSIO_n157 2.93626
R320 VSSIO_n118 VSSIO_n117 2.93626
R321 VSSIO_n158 VSSIO_t151 2.3945
R322 VSSIO_n169 VSSIO_t79 2.3945
R323 VSSIO_n117 VSSIO_t7 2.3945
R324 VSSIO_n194 VSSIO_t88 2.3945
R325 VSSIO_n1 VSSIO_n0 2.3405
R326 VSSIO_n64 VSSIO_t48 1.563
R327 VSSIO VSSIO_n1 1.4405
R328 VSSIO_n88 VSSIO_n87 1.06277
R329 VSSIO_n202 VSSIO_n21 0.9995
R330 VSSIO_n136 VSSIO_t127 0.8195
R331 VSSIO_n136 VSSIO_t145 0.8195
R332 VSSIO_n135 VSSIO_t142 0.8195
R333 VSSIO_n135 VSSIO_t133 0.8195
R334 VSSIO_n134 VSSIO_t136 0.8195
R335 VSSIO_n134 VSSIO_t139 0.8195
R336 VSSIO_n133 VSSIO_t124 0.8195
R337 VSSIO_n133 VSSIO_t130 0.8195
R338 VSSIO_n132 VSSIO_t121 0.8195
R339 VSSIO_n132 VSSIO_t118 0.8195
R340 VSSIO_n131 VSSIO_t112 0.8195
R341 VSSIO_n131 VSSIO_t115 0.8195
R342 VSSIO_n130 VSSIO_t97 0.8195
R343 VSSIO_n130 VSSIO_t109 0.8195
R344 VSSIO_n129 VSSIO_t106 0.8195
R345 VSSIO_n129 VSSIO_t100 0.8195
R346 VSSIO_n128 VSSIO_t91 0.8195
R347 VSSIO_n128 VSSIO_t103 0.8195
R348 VSSIO_n167 VSSIO_t202 0.8195
R349 VSSIO_n167 VSSIO_t196 0.8195
R350 VSSIO_n166 VSSIO_t193 0.8195
R351 VSSIO_n166 VSSIO_t199 0.8195
R352 VSSIO_n165 VSSIO_t181 0.8195
R353 VSSIO_n165 VSSIO_t190 0.8195
R354 VSSIO_n164 VSSIO_t184 0.8195
R355 VSSIO_n164 VSSIO_t187 0.8195
R356 VSSIO_n163 VSSIO_t175 0.8195
R357 VSSIO_n163 VSSIO_t178 0.8195
R358 VSSIO_n162 VSSIO_t172 0.8195
R359 VSSIO_n162 VSSIO_t169 0.8195
R360 VSSIO_n161 VSSIO_t163 0.8195
R361 VSSIO_n161 VSSIO_t166 0.8195
R362 VSSIO_n160 VSSIO_t157 0.8195
R363 VSSIO_n160 VSSIO_t160 0.8195
R364 VSSIO_n159 VSSIO_t94 0.8195
R365 VSSIO_n159 VSSIO_t154 0.8195
R366 VSSIO_n51 VSSIO_t39 0.8195
R367 VSSIO_n51 VSSIO_t83 0.8195
R368 VSSIO_n50 VSSIO_t227 0.8195
R369 VSSIO_n50 VSSIO_t217 0.8195
R370 VSSIO_n49 VSSIO_t31 0.8195
R371 VSSIO_n49 VSSIO_t37 0.8195
R372 VSSIO_n48 VSSIO_t211 0.8195
R373 VSSIO_n48 VSSIO_t15 0.8195
R374 VSSIO_n47 VSSIO_t225 0.8195
R375 VSSIO_n47 VSSIO_t64 0.8195
R376 VSSIO_n46 VSSIO_t35 0.8195
R377 VSSIO_n46 VSSIO_t43 0.8195
R378 VSSIO_n45 VSSIO_t13 0.8195
R379 VSSIO_n45 VSSIO_t29 0.8195
R380 VSSIO_n44 VSSIO_t5 0.8195
R381 VSSIO_n44 VSSIO_t58 0.8195
R382 VSSIO_n43 VSSIO_t51 0.8195
R383 VSSIO_n43 VSSIO_t21 0.8195
R384 VSSIO_n42 VSSIO_t62 0.8195
R385 VSSIO_n42 VSSIO_t215 0.8195
R386 VSSIO_n41 VSSIO_t41 0.8195
R387 VSSIO_n41 VSSIO_t223 0.8195
R388 VSSIO_n40 VSSIO_t56 0.8195
R389 VSSIO_n40 VSSIO_t33 0.8195
R390 VSSIO_n39 VSSIO_t213 0.8195
R391 VSSIO_n39 VSSIO_t49 0.8195
R392 VSSIO_n38 VSSIO_t45 0.8195
R393 VSSIO_n38 VSSIO_t47 0.8195
R394 VSSIO_n37 VSSIO_t11 0.8195
R395 VSSIO_n37 VSSIO_t27 0.8195
R396 VSSIO_n36 VSSIO_t19 0.8195
R397 VSSIO_n36 VSSIO_t3 0.8195
R398 VSSIO_n35 VSSIO_t25 0.8195
R399 VSSIO_n35 VSSIO_t72 0.8195
R400 VSSIO_n34 VSSIO_t1 0.8195
R401 VSSIO_n34 VSSIO_t9 0.8195
R402 VSSIO_n33 VSSIO_t23 0.8195
R403 VSSIO_n33 VSSIO_t17 0.8195
R404 VSSIO_n89 VSSIO_n88 0.7625
R405 VSSIO_n94 VSSIO_n93 0.6005
R406 VSSIO_n95 VSSIO_n94 0.6005
R407 VSSIO_n96 VSSIO_n95 0.6005
R408 VSSIO_n106 VSSIO_n62 0.6005
R409 VSSIO_n93 VSSIO_n92 0.5855
R410 VSSIO_n97 VSSIO_n62 0.5855
R411 VSSIO_n90 VSSIO_n89 0.4655
R412 VSSIO_n92 VSSIO_n91 0.4655
R413 VSSIO_n97 VSSIO_n96 0.4655
R414 VSSIO_n106 VSSIO_n105 0.462773
R415 VSSIO_n101 VSSIO_n62 0.462773
R416 VSSIO_n98 VSSIO_n97 0.462773
R417 VSSIO_n96 VSSIO_n67 0.462773
R418 VSSIO_n95 VSSIO_n73 0.462773
R419 VSSIO_n94 VSSIO_n75 0.462773
R420 VSSIO_n93 VSSIO_n77 0.462773
R421 VSSIO_n92 VSSIO_n79 0.462773
R422 VSSIO_n91 VSSIO_n81 0.462773
R423 VSSIO_n90 VSSIO_n83 0.462773
R424 VSSIO_n88 VSSIO_n86 0.462773
R425 VSSIO_n91 VSSIO_n90 0.4235
R426 VSSIO_n116 VSSIO_n115 0.3605
R427 VSSIO_n115 VSSIO_n114 0.3605
R428 VSSIO_n114 VSSIO_n113 0.3605
R429 VSSIO_n113 VSSIO_n112 0.3605
R430 VSSIO_n112 VSSIO_n111 0.3605
R431 VSSIO_n111 VSSIO_n110 0.3605
R432 VSSIO_n110 VSSIO_n109 0.3605
R433 VSSIO_n109 VSSIO_n108 0.3605
R434 VSSIO_n61 VSSIO_n60 0.3605
R435 VSSIO_n60 VSSIO_n59 0.3605
R436 VSSIO_n59 VSSIO_n58 0.3605
R437 VSSIO_n58 VSSIO_n57 0.3605
R438 VSSIO_n57 VSSIO_n56 0.3605
R439 VSSIO_n56 VSSIO_n55 0.3605
R440 VSSIO_n55 VSSIO_n54 0.3605
R441 VSSIO_n54 VSSIO_n53 0.3605
R442 VSSIO_n53 VSSIO_n52 0.3605
R443 VSSIO VSSIO_n116 0.35825
R444 VSSIO_n52 VSSIO_n22 0.32225
R445 VSSIO_n108 VSSIO_n107 0.32
R446 VSSIO_n182 VSSIO_n181 0.232281
R447 VSSIO VSSIO_n200 0.221777
R448 VSSIO_n193 VSSIO_n192 0.19776
R449 VSSIO_n192 VSSIO_n191 0.19776
R450 VSSIO_n191 VSSIO_n190 0.19776
R451 VSSIO_n190 VSSIO_n189 0.19776
R452 VSSIO_n189 VSSIO_n188 0.19776
R453 VSSIO_n188 VSSIO_n187 0.19776
R454 VSSIO_n187 VSSIO_n186 0.19776
R455 VSSIO_n186 VSSIO_n185 0.19776
R456 VSSIO_n185 VSSIO_n184 0.19776
R457 VSSIO_n184 VSSIO_n183 0.19776
R458 VSSIO_n181 VSSIO_n180 0.19776
R459 VSSIO_n180 VSSIO_n179 0.19776
R460 VSSIO_n179 VSSIO_n178 0.19776
R461 VSSIO_n178 VSSIO_n177 0.19776
R462 VSSIO_n177 VSSIO_n176 0.19776
R463 VSSIO_n176 VSSIO_n175 0.19776
R464 VSSIO_n175 VSSIO_n174 0.19776
R465 VSSIO_n174 VSSIO_n173 0.19776
R466 VSSIO_n173 VSSIO_n172 0.19776
R467 VSSIO_n172 VSSIO_n171 0.19776
R468 VSSIO_n183 VSSIO_n182 0.189315
R469 VSSIO_n193 VSSIO_n21 0.121322
R470 VSSIO VSSIO_n202 0.1085
R471 VSSIO_n107 VSSIO_n61 0.041
R472 VSSIO_n170 VSSIO 0.0272021
R473 VSSIO VSSIO_t232 0.0122914
R474 IN IN_t0 9.17375
R475 IN IN_t1 8.13509
R476 PAD_n54 PAD_t41 108.495
R477 PAD_n54 PAD_t42 75.5435
R478 PAD_n41 PAD_n21 10.6494
R479 PAD_n55 PAD_n54 10.1705
R480 PAD_n104 PAD 7.7513
R481 PAD_n102 PAD 7.54362
R482 PAD_n31 PAD_n30 7.02725
R483 PAD_n18 PAD_n17 7.02725
R484 PAD_n9 PAD_n8 7.02725
R485 PAD_n41 PAD_n40 6.97229
R486 PAD_n40 PAD_n39 6.89675
R487 PAD_n38 PAD_n22 6.66725
R488 PAD_n37 PAD_n23 6.66725
R489 PAD_n36 PAD_n24 6.66725
R490 PAD_n35 PAD_n25 6.66725
R491 PAD_n34 PAD_n26 6.66725
R492 PAD_n33 PAD_n27 6.66725
R493 PAD_n32 PAD_n28 6.66725
R494 PAD_n31 PAD_n29 6.66725
R495 PAD_n18 PAD_n16 6.66725
R496 PAD_n19 PAD_n15 6.66725
R497 PAD_n20 PAD_n14 6.66725
R498 PAD_n13 PAD_n3 6.66725
R499 PAD_n12 PAD_n4 6.66725
R500 PAD_n11 PAD_n5 6.66725
R501 PAD_n10 PAD_n6 6.66725
R502 PAD_n9 PAD_n7 6.66725
R503 PAD_n57 PAD_n55 4.5005
R504 PAD_n195 PAD_n41 2.03232
R505 PAD PAD_n198 1.3199
R506 PAD_n198 PAD 1.3199
R507 PAD_n198 PAD 1.3199
R508 PAD_n39 PAD_t21 0.8195
R509 PAD_n39 PAD_t22 0.8195
R510 PAD_n22 PAD_t23 0.8195
R511 PAD_n22 PAD_t24 0.8195
R512 PAD_n23 PAD_t25 0.8195
R513 PAD_n23 PAD_t26 0.8195
R514 PAD_n24 PAD_t27 0.8195
R515 PAD_n24 PAD_t28 0.8195
R516 PAD_n25 PAD_t29 0.8195
R517 PAD_n25 PAD_t30 0.8195
R518 PAD_n26 PAD_t31 0.8195
R519 PAD_n26 PAD_t32 0.8195
R520 PAD_n27 PAD_t33 0.8195
R521 PAD_n27 PAD_t34 0.8195
R522 PAD_n28 PAD_t35 0.8195
R523 PAD_n28 PAD_t36 0.8195
R524 PAD_n29 PAD_t37 0.8195
R525 PAD_n29 PAD_t38 0.8195
R526 PAD_n30 PAD_t39 0.8195
R527 PAD_n30 PAD_t40 0.8195
R528 PAD_n17 PAD_t1 0.8195
R529 PAD_n17 PAD_t2 0.8195
R530 PAD_n16 PAD_t3 0.8195
R531 PAD_n16 PAD_t4 0.8195
R532 PAD_n15 PAD_t5 0.8195
R533 PAD_n15 PAD_t6 0.8195
R534 PAD_n14 PAD_t7 0.8195
R535 PAD_n14 PAD_t8 0.8195
R536 PAD_n3 PAD_t9 0.8195
R537 PAD_n3 PAD_t10 0.8195
R538 PAD_n4 PAD_t11 0.8195
R539 PAD_n4 PAD_t12 0.8195
R540 PAD_n5 PAD_t13 0.8195
R541 PAD_n5 PAD_t14 0.8195
R542 PAD_n6 PAD_t15 0.8195
R543 PAD_n6 PAD_t16 0.8195
R544 PAD_n7 PAD_t17 0.8195
R545 PAD_n7 PAD_t18 0.8195
R546 PAD_n8 PAD_t19 0.8195
R547 PAD_n8 PAD_t20 0.8195
R548 PAD_n38 PAD_n37 0.3605
R549 PAD_n37 PAD_n36 0.3605
R550 PAD_n36 PAD_n35 0.3605
R551 PAD_n35 PAD_n34 0.3605
R552 PAD_n34 PAD_n33 0.3605
R553 PAD_n33 PAD_n32 0.3605
R554 PAD_n32 PAD_n31 0.3605
R555 PAD_n19 PAD_n18 0.3605
R556 PAD_n20 PAD_n19 0.3605
R557 PAD_n13 PAD_n12 0.3605
R558 PAD_n12 PAD_n11 0.3605
R559 PAD_n11 PAD_n10 0.3605
R560 PAD_n10 PAD_n9 0.3605
R561 PAD_n21 PAD_n13 0.3335
R562 PAD PAD_t0 0.280213
R563 PAD_n195 PAD_n194 0.143024
R564 PAD_n109 PAD_n102 0.143024
R565 PAD_n103 PAD_n102 0.141125
R566 PAD_n196 PAD_n195 0.141125
R567 PAD_n2 PAD_n1 0.141125
R568 PAD_n191 PAD_n190 0.141125
R569 PAD_n46 PAD_n45 0.141125
R570 PAD_n186 PAD_n185 0.141125
R571 PAD_n49 PAD_n48 0.141125
R572 PAD_n179 PAD_n178 0.141125
R573 PAD_n56 PAD_n53 0.141125
R574 PAD_n174 PAD_n173 0.141125
R575 PAD_n60 PAD_n59 0.141125
R576 PAD_n167 PAD_n166 0.141125
R577 PAD_n65 PAD_n64 0.141125
R578 PAD_n162 PAD_n161 0.141125
R579 PAD_n68 PAD_n67 0.141125
R580 PAD_n155 PAD_n154 0.141125
R581 PAD_n73 PAD_n72 0.141125
R582 PAD_n150 PAD_n149 0.141125
R583 PAD_n76 PAD_n75 0.141125
R584 PAD_n143 PAD_n142 0.141125
R585 PAD_n81 PAD_n80 0.141125
R586 PAD_n138 PAD_n137 0.141125
R587 PAD_n84 PAD_n83 0.141125
R588 PAD_n131 PAD_n130 0.141125
R589 PAD_n89 PAD_n88 0.141125
R590 PAD_n126 PAD_n125 0.141125
R591 PAD_n92 PAD_n91 0.141125
R592 PAD_n119 PAD_n118 0.141125
R593 PAD_n97 PAD_n96 0.141125
R594 PAD_n114 PAD_n113 0.141125
R595 PAD_n100 PAD_n99 0.141125
R596 PAD_n107 PAD_n106 0.141125
R597 PAD_n106 PAD_n105 0.141125
R598 PAD_n99 PAD_n98 0.141125
R599 PAD_n115 PAD_n114 0.141125
R600 PAD_n116 PAD_n97 0.141125
R601 PAD_n118 PAD_n117 0.141125
R602 PAD_n91 PAD_n90 0.141125
R603 PAD_n127 PAD_n126 0.141125
R604 PAD_n128 PAD_n89 0.141125
R605 PAD_n130 PAD_n129 0.141125
R606 PAD_n83 PAD_n82 0.141125
R607 PAD_n139 PAD_n138 0.141125
R608 PAD_n140 PAD_n81 0.141125
R609 PAD_n142 PAD_n141 0.141125
R610 PAD_n75 PAD_n74 0.141125
R611 PAD_n151 PAD_n150 0.141125
R612 PAD_n152 PAD_n73 0.141125
R613 PAD_n154 PAD_n153 0.141125
R614 PAD_n67 PAD_n66 0.141125
R615 PAD_n163 PAD_n162 0.141125
R616 PAD_n164 PAD_n65 0.141125
R617 PAD_n166 PAD_n165 0.141125
R618 PAD_n59 PAD_n58 0.141125
R619 PAD_n175 PAD_n174 0.141125
R620 PAD_n176 PAD_n56 0.141125
R621 PAD_n178 PAD_n177 0.141125
R622 PAD_n48 PAD_n47 0.141125
R623 PAD_n187 PAD_n186 0.141125
R624 PAD_n188 PAD_n46 0.141125
R625 PAD_n190 PAD_n189 0.141125
R626 PAD_n1 PAD_n0 0.141125
R627 PAD_n197 PAD_n196 0.141125
R628 PAD_n42 PAD_n2 0.141125
R629 PAD_n192 PAD_n191 0.141125
R630 PAD_n45 PAD_n44 0.141125
R631 PAD_n185 PAD_n184 0.141125
R632 PAD_n50 PAD_n49 0.141125
R633 PAD_n180 PAD_n179 0.141125
R634 PAD_n53 PAD_n52 0.141125
R635 PAD_n173 PAD_n172 0.141125
R636 PAD_n61 PAD_n60 0.141125
R637 PAD_n168 PAD_n167 0.141125
R638 PAD_n64 PAD_n63 0.141125
R639 PAD_n161 PAD_n160 0.141125
R640 PAD_n69 PAD_n68 0.141125
R641 PAD_n156 PAD_n155 0.141125
R642 PAD_n72 PAD_n71 0.141125
R643 PAD_n149 PAD_n148 0.141125
R644 PAD_n77 PAD_n76 0.141125
R645 PAD_n144 PAD_n143 0.141125
R646 PAD_n80 PAD_n79 0.141125
R647 PAD_n137 PAD_n136 0.141125
R648 PAD_n85 PAD_n84 0.141125
R649 PAD_n132 PAD_n131 0.141125
R650 PAD_n88 PAD_n87 0.141125
R651 PAD_n125 PAD_n124 0.141125
R652 PAD_n93 PAD_n92 0.141125
R653 PAD_n120 PAD_n119 0.141125
R654 PAD_n96 PAD_n95 0.141125
R655 PAD_n113 PAD_n112 0.141125
R656 PAD_n101 PAD_n100 0.141125
R657 PAD_n108 PAD_n107 0.141125
R658 PAD_n193 PAD_n192 0.141125
R659 PAD_n44 PAD_n43 0.141125
R660 PAD_n184 PAD_n183 0.141125
R661 PAD_n182 PAD_n50 0.141125
R662 PAD_n181 PAD_n180 0.141125
R663 PAD_n52 PAD_n51 0.141125
R664 PAD_n172 PAD_n171 0.141125
R665 PAD_n170 PAD_n61 0.141125
R666 PAD_n169 PAD_n168 0.141125
R667 PAD_n63 PAD_n62 0.141125
R668 PAD_n160 PAD_n159 0.141125
R669 PAD_n158 PAD_n69 0.141125
R670 PAD_n157 PAD_n156 0.141125
R671 PAD_n71 PAD_n70 0.141125
R672 PAD_n148 PAD_n147 0.141125
R673 PAD_n146 PAD_n77 0.141125
R674 PAD_n145 PAD_n144 0.141125
R675 PAD_n79 PAD_n78 0.141125
R676 PAD_n136 PAD_n135 0.141125
R677 PAD_n134 PAD_n85 0.141125
R678 PAD_n133 PAD_n132 0.141125
R679 PAD_n87 PAD_n86 0.141125
R680 PAD_n124 PAD_n123 0.141125
R681 PAD_n122 PAD_n93 0.141125
R682 PAD_n121 PAD_n120 0.141125
R683 PAD_n95 PAD_n94 0.141125
R684 PAD_n112 PAD_n111 0.141125
R685 PAD_n110 PAD_n101 0.141125
R686 PAD_n105 PAD_n104 0.140157
R687 PAD_n40 PAD_n38 0.131
R688 PAD_n194 PAD_n193 0.0721774
R689 PAD_n110 PAD_n109 0.0721774
R690 PAD_n21 PAD_n20 0.0275
R691 PAD PAD_t43 0.0251094
R692 PAD PAD_t44 0.0251094
R693 PAD PAD_t45 0.0208125
R694 PAD_n196 PAD_n1 0.0033125
R695 PAD_n190 PAD_n1 0.0033125
R696 PAD_n190 PAD_n46 0.0033125
R697 PAD_n186 PAD_n46 0.0033125
R698 PAD_n186 PAD_n48 0.0033125
R699 PAD_n178 PAD_n56 0.0033125
R700 PAD_n174 PAD_n56 0.0033125
R701 PAD_n174 PAD_n59 0.0033125
R702 PAD_n166 PAD_n59 0.0033125
R703 PAD_n166 PAD_n65 0.0033125
R704 PAD_n162 PAD_n65 0.0033125
R705 PAD_n162 PAD_n67 0.0033125
R706 PAD_n154 PAD_n67 0.0033125
R707 PAD_n154 PAD_n73 0.0033125
R708 PAD_n150 PAD_n73 0.0033125
R709 PAD_n150 PAD_n75 0.0033125
R710 PAD_n142 PAD_n75 0.0033125
R711 PAD_n142 PAD_n81 0.0033125
R712 PAD_n138 PAD_n81 0.0033125
R713 PAD_n138 PAD_n83 0.0033125
R714 PAD_n130 PAD_n83 0.0033125
R715 PAD_n130 PAD_n89 0.0033125
R716 PAD_n126 PAD_n89 0.0033125
R717 PAD_n126 PAD_n91 0.0033125
R718 PAD_n118 PAD_n91 0.0033125
R719 PAD_n118 PAD_n97 0.0033125
R720 PAD_n114 PAD_n97 0.0033125
R721 PAD_n114 PAD_n99 0.0033125
R722 PAD_n106 PAD_n99 0.0033125
R723 PAD_n106 PAD_n103 0.0033125
R724 PAD_n197 PAD_n0 0.0033125
R725 PAD_n189 PAD_n0 0.0033125
R726 PAD_n189 PAD_n188 0.0033125
R727 PAD_n188 PAD_n187 0.0033125
R728 PAD_n187 PAD_n47 0.0033125
R729 PAD_n177 PAD_n47 0.0033125
R730 PAD_n177 PAD_n176 0.0033125
R731 PAD_n176 PAD_n175 0.0033125
R732 PAD_n175 PAD_n58 0.0033125
R733 PAD_n165 PAD_n58 0.0033125
R734 PAD_n165 PAD_n164 0.0033125
R735 PAD_n164 PAD_n163 0.0033125
R736 PAD_n163 PAD_n66 0.0033125
R737 PAD_n153 PAD_n66 0.0033125
R738 PAD_n153 PAD_n152 0.0033125
R739 PAD_n152 PAD_n151 0.0033125
R740 PAD_n151 PAD_n74 0.0033125
R741 PAD_n141 PAD_n74 0.0033125
R742 PAD_n141 PAD_n140 0.0033125
R743 PAD_n140 PAD_n139 0.0033125
R744 PAD_n139 PAD_n82 0.0033125
R745 PAD_n129 PAD_n82 0.0033125
R746 PAD_n129 PAD_n128 0.0033125
R747 PAD_n128 PAD_n127 0.0033125
R748 PAD_n127 PAD_n90 0.0033125
R749 PAD_n117 PAD_n90 0.0033125
R750 PAD_n117 PAD_n116 0.0033125
R751 PAD_n116 PAD_n115 0.0033125
R752 PAD_n115 PAD_n98 0.0033125
R753 PAD_n105 PAD_n98 0.0033125
R754 PAD_n195 PAD_n2 0.0033125
R755 PAD_n191 PAD_n2 0.0033125
R756 PAD_n191 PAD_n45 0.0033125
R757 PAD_n185 PAD_n45 0.0033125
R758 PAD_n185 PAD_n49 0.0033125
R759 PAD_n179 PAD_n53 0.0033125
R760 PAD_n173 PAD_n53 0.0033125
R761 PAD_n173 PAD_n60 0.0033125
R762 PAD_n167 PAD_n60 0.0033125
R763 PAD_n167 PAD_n64 0.0033125
R764 PAD_n161 PAD_n64 0.0033125
R765 PAD_n161 PAD_n68 0.0033125
R766 PAD_n155 PAD_n68 0.0033125
R767 PAD_n155 PAD_n72 0.0033125
R768 PAD_n149 PAD_n72 0.0033125
R769 PAD_n149 PAD_n76 0.0033125
R770 PAD_n143 PAD_n76 0.0033125
R771 PAD_n143 PAD_n80 0.0033125
R772 PAD_n137 PAD_n80 0.0033125
R773 PAD_n137 PAD_n84 0.0033125
R774 PAD_n131 PAD_n84 0.0033125
R775 PAD_n131 PAD_n88 0.0033125
R776 PAD_n125 PAD_n88 0.0033125
R777 PAD_n125 PAD_n92 0.0033125
R778 PAD_n119 PAD_n92 0.0033125
R779 PAD_n119 PAD_n96 0.0033125
R780 PAD_n113 PAD_n96 0.0033125
R781 PAD_n113 PAD_n100 0.0033125
R782 PAD_n107 PAD_n100 0.0033125
R783 PAD_n107 PAD_n102 0.0033125
R784 PAD_n192 PAD_n42 0.0033125
R785 PAD_n192 PAD_n44 0.0033125
R786 PAD_n184 PAD_n44 0.0033125
R787 PAD_n184 PAD_n50 0.0033125
R788 PAD_n180 PAD_n50 0.0033125
R789 PAD_n180 PAD_n52 0.0033125
R790 PAD_n172 PAD_n52 0.0033125
R791 PAD_n172 PAD_n61 0.0033125
R792 PAD_n168 PAD_n61 0.0033125
R793 PAD_n168 PAD_n63 0.0033125
R794 PAD_n160 PAD_n63 0.0033125
R795 PAD_n160 PAD_n69 0.0033125
R796 PAD_n156 PAD_n69 0.0033125
R797 PAD_n156 PAD_n71 0.0033125
R798 PAD_n148 PAD_n71 0.0033125
R799 PAD_n148 PAD_n77 0.0033125
R800 PAD_n144 PAD_n77 0.0033125
R801 PAD_n144 PAD_n79 0.0033125
R802 PAD_n136 PAD_n79 0.0033125
R803 PAD_n136 PAD_n85 0.0033125
R804 PAD_n132 PAD_n85 0.0033125
R805 PAD_n132 PAD_n87 0.0033125
R806 PAD_n124 PAD_n87 0.0033125
R807 PAD_n124 PAD_n93 0.0033125
R808 PAD_n120 PAD_n93 0.0033125
R809 PAD_n120 PAD_n95 0.0033125
R810 PAD_n112 PAD_n95 0.0033125
R811 PAD_n112 PAD_n101 0.0033125
R812 PAD_n108 PAD_n101 0.0033125
R813 PAD_n57 PAD_n48 0.00256719
R814 PAD_n55 PAD_n49 0.00256719
R815 PAD_n194 PAD_n42 0.00238623
R816 PAD_n109 PAD_n108 0.00238623
R817 PAD_n193 PAD_n43 0.00175
R818 PAD_n183 PAD_n43 0.00175
R819 PAD_n183 PAD_n182 0.00175
R820 PAD_n182 PAD_n181 0.00175
R821 PAD_n181 PAD_n51 0.00175
R822 PAD_n171 PAD_n51 0.00175
R823 PAD_n171 PAD_n170 0.00175
R824 PAD_n170 PAD_n169 0.00175
R825 PAD_n169 PAD_n62 0.00175
R826 PAD_n159 PAD_n62 0.00175
R827 PAD_n159 PAD_n158 0.00175
R828 PAD_n158 PAD_n157 0.00175
R829 PAD_n157 PAD_n70 0.00175
R830 PAD_n147 PAD_n70 0.00175
R831 PAD_n147 PAD_n146 0.00175
R832 PAD_n146 PAD_n145 0.00175
R833 PAD_n145 PAD_n78 0.00175
R834 PAD_n135 PAD_n78 0.00175
R835 PAD_n135 PAD_n134 0.00175
R836 PAD_n134 PAD_n133 0.00175
R837 PAD_n133 PAD_n86 0.00175
R838 PAD_n123 PAD_n86 0.00175
R839 PAD_n123 PAD_n122 0.00175
R840 PAD_n122 PAD_n121 0.00175
R841 PAD_n121 PAD_n94 0.00175
R842 PAD_n111 PAD_n94 0.00175
R843 PAD_n111 PAD_n110 0.00175
R844 PAD_n178 PAD_n57 0.00124531
R845 PAD_n198 PAD_n197 0.00124531
R846 PAD_n179 PAD_n55 0.00124531
R847 PAD_n104 PAD_n103 0.00102002
R848 GN_n0 GN_t2 44.2698
R849 GN_n40 GN_n39 38.8567
R850 GN_n40 GN_n38 38.2238
R851 GN_n0 GN_t3 32.5898
R852 GN_n1 GN_t4 32.5898
R853 GN_n2 GN_t5 32.5898
R854 GN_n3 GN_t6 32.5898
R855 GN_n4 GN_t7 32.5898
R856 GN_n5 GN_t8 32.5898
R857 GN_n6 GN_t9 32.5898
R858 GN_n7 GN_t10 32.5898
R859 GN_n8 GN_t11 32.5898
R860 GN_n9 GN_t12 32.5898
R861 GN_n10 GN_t13 32.5898
R862 GN_n11 GN_t14 32.5898
R863 GN_n12 GN_t15 32.5898
R864 GN_n13 GN_t16 32.5898
R865 GN_n14 GN_t17 32.5898
R866 GN_n15 GN_t18 32.5898
R867 GN_n16 GN_t19 32.5898
R868 GN_n17 GN_t20 32.5898
R869 GN_n18 GN_t21 32.5898
R870 GN_n19 GN_t22 32.5898
R871 GN_n20 GN_t23 32.5898
R872 GN_n21 GN_t24 32.5898
R873 GN_n22 GN_t25 32.5898
R874 GN_n23 GN_t26 32.5898
R875 GN_n24 GN_t27 32.5898
R876 GN_n25 GN_t28 32.5898
R877 GN_n26 GN_t29 32.5898
R878 GN_n27 GN_t30 32.5898
R879 GN_n28 GN_t31 32.5898
R880 GN_n29 GN_t32 32.5898
R881 GN_n30 GN_t33 32.5898
R882 GN_n31 GN_t34 32.5898
R883 GN_n32 GN_t35 32.5898
R884 GN_n33 GN_t36 32.5898
R885 GN_n34 GN_t37 32.5898
R886 GN_n35 GN_t38 32.5898
R887 GN_n36 GN_t39 32.5898
R888 GN_n37 GN_t40 32.5898
R889 GN_n38 GN_t41 32.5898
R890 GN_n38 GN_n37 11.6805
R891 GN_n37 GN_n36 11.6805
R892 GN_n36 GN_n35 11.6805
R893 GN_n35 GN_n34 11.6805
R894 GN_n34 GN_n33 11.6805
R895 GN_n33 GN_n32 11.6805
R896 GN_n32 GN_n31 11.6805
R897 GN_n31 GN_n30 11.6805
R898 GN_n30 GN_n29 11.6805
R899 GN_n29 GN_n28 11.6805
R900 GN_n28 GN_n27 11.6805
R901 GN_n27 GN_n26 11.6805
R902 GN_n26 GN_n25 11.6805
R903 GN_n25 GN_n24 11.6805
R904 GN_n24 GN_n23 11.6805
R905 GN_n23 GN_n22 11.6805
R906 GN_n22 GN_n21 11.6805
R907 GN_n21 GN_n20 11.6805
R908 GN_n20 GN_n19 11.6805
R909 GN_n19 GN_n18 11.6805
R910 GN_n18 GN_n17 11.6805
R911 GN_n17 GN_n16 11.6805
R912 GN_n16 GN_n15 11.6805
R913 GN_n15 GN_n14 11.6805
R914 GN_n14 GN_n13 11.6805
R915 GN_n13 GN_n12 11.6805
R916 GN_n12 GN_n11 11.6805
R917 GN_n11 GN_n10 11.6805
R918 GN_n10 GN_n9 11.6805
R919 GN_n9 GN_n8 11.6805
R920 GN_n8 GN_n7 11.6805
R921 GN_n7 GN_n6 11.6805
R922 GN_n6 GN_n5 11.6805
R923 GN_n5 GN_n4 11.6805
R924 GN_n4 GN_n3 11.6805
R925 GN_n3 GN_n2 11.6805
R926 GN_n2 GN_n1 11.6805
R927 GN_n1 GN_n0 11.6805
R928 GN_n39 GN_t0 5.15205
R929 GN_n39 GN_t1 2.69247
R930 GN GN_n40 0.0262143
R931 GP_n0 GP_t2 88.5912
R932 GP_n0 GP_t3 76.9112
R933 GP_n1 GP_t4 76.9112
R934 GP_n2 GP_t5 76.9112
R935 GP_n3 GP_t6 76.9112
R936 GP_n4 GP_t7 76.9112
R937 GP_n5 GP_t8 76.9112
R938 GP_n6 GP_t9 76.9112
R939 GP_n7 GP_t10 76.9112
R940 GP_n8 GP_t11 76.9112
R941 GP_n9 GP_t12 76.9112
R942 GP_n10 GP_t13 76.9112
R943 GP_n11 GP_t14 76.9112
R944 GP_n12 GP_t15 76.9112
R945 GP_n13 GP_t16 76.9112
R946 GP_n14 GP_t17 76.9112
R947 GP_n15 GP_t18 76.9112
R948 GP_n16 GP_t19 76.9112
R949 GP_n17 GP_t20 76.9112
R950 GP_n18 GP_t21 76.9112
R951 GP_n19 GP_t22 76.9112
R952 GP_n20 GP_t23 76.9112
R953 GP_n21 GP_t24 76.9112
R954 GP_n22 GP_t25 76.9112
R955 GP_n23 GP_t26 76.9112
R956 GP_n24 GP_t27 76.9112
R957 GP_n25 GP_t28 76.9112
R958 GP_n26 GP_t29 76.9112
R959 GP_n27 GP_t30 76.9112
R960 GP_n28 GP_t31 76.9112
R961 GP_n29 GP_t32 76.9112
R962 GP_n30 GP_t33 76.9112
R963 GP_n31 GP_t34 76.9112
R964 GP_n32 GP_t35 76.9112
R965 GP_n33 GP_t36 76.9112
R966 GP_n34 GP_t37 76.9112
R967 GP_n35 GP_t38 76.9112
R968 GP_n36 GP_t39 76.9112
R969 GP_n37 GP_t40 76.9112
R970 GP_n38 GP_t41 76.9112
R971 GP_n40 GP_n39 41.6287
R972 GP_n40 GP_n38 38.2238
R973 GP_n38 GP_n37 11.6805
R974 GP_n37 GP_n36 11.6805
R975 GP_n36 GP_n35 11.6805
R976 GP_n35 GP_n34 11.6805
R977 GP_n34 GP_n33 11.6805
R978 GP_n33 GP_n32 11.6805
R979 GP_n32 GP_n31 11.6805
R980 GP_n31 GP_n30 11.6805
R981 GP_n30 GP_n29 11.6805
R982 GP_n29 GP_n28 11.6805
R983 GP_n28 GP_n27 11.6805
R984 GP_n27 GP_n26 11.6805
R985 GP_n26 GP_n25 11.6805
R986 GP_n25 GP_n24 11.6805
R987 GP_n24 GP_n23 11.6805
R988 GP_n23 GP_n22 11.6805
R989 GP_n22 GP_n21 11.6805
R990 GP_n21 GP_n20 11.6805
R991 GP_n20 GP_n19 11.6805
R992 GP_n19 GP_n18 11.6805
R993 GP_n18 GP_n17 11.6805
R994 GP_n17 GP_n16 11.6805
R995 GP_n16 GP_n15 11.6805
R996 GP_n15 GP_n14 11.6805
R997 GP_n14 GP_n13 11.6805
R998 GP_n13 GP_n12 11.6805
R999 GP_n12 GP_n11 11.6805
R1000 GP_n11 GP_n10 11.6805
R1001 GP_n10 GP_n9 11.6805
R1002 GP_n9 GP_n8 11.6805
R1003 GP_n8 GP_n7 11.6805
R1004 GP_n7 GP_n6 11.6805
R1005 GP_n6 GP_n5 11.6805
R1006 GP_n5 GP_n4 11.6805
R1007 GP_n4 GP_n3 11.6805
R1008 GP_n3 GP_n2 11.6805
R1009 GP_n2 GP_n1 11.6805
R1010 GP_n1 GP_n0 11.6805
R1011 GP_n39 GP_t1 5.15205
R1012 GP_n39 GP_t0 2.69247
R1013 GP GP_n40 0.0262143
R1014 PU_OK_t1 PU_OK_t0 119.407
R1015 PU_OK PU_OK_t1 52.6952
R1016 OE_N_t1 OE_N_t0 96.4648
R1017 OE_N OE_N_t1 53.144
R1018 OUT_t3 OUT_t1 96.4648
R1019 OUT_t2 OUT_t0 96.4648
R1020 OUT_n0 OUT_t2 47.237
R1021 OUT_n0 OUT_t3 40.559
R1022 OUT OUT_n0 12.8255
R1023 VDDIO VDDIO_t100 526.747
R1024 VDDIO VDDIO_t98 521.779
R1025 VDDIO_n42 VDDIO_t82 395.611
R1026 VDDIO_n43 VDDIO_t85 395.503
R1027 VDDIO_n45 VDDIO_t104 395.503
R1028 VDDIO_n47 VDDIO_t108 395.503
R1029 VDDIO_n41 VDDIO_t89 395.503
R1030 VDDIO_n39 VDDIO_t93 395.503
R1031 VDDIO_n38 VDDIO_t91 395.503
R1032 VDDIO_n36 VDDIO_t106 395.503
R1033 VDDIO_n34 VDDIO_t87 395.503
R1034 VDDIO_n32 VDDIO_t80 395.503
R1035 VDDIO_n30 VDDIO_t84 395.503
R1036 VDDIO_n29 VDDIO_t94 395.503
R1037 VDDIO_n27 VDDIO_t96 395.503
R1038 VDDIO_n66 VDDIO_t102 232.214
R1039 VDDIO_n0 VDDIO_t0 192.674
R1040 VDDIO_t0 VDDIO_t2 136.519
R1041 VDDIO_t2 VDDIO_t8 136.519
R1042 VDDIO_t8 VDDIO_t4 136.519
R1043 VDDIO_t4 VDDIO_t10 136.519
R1044 VDDIO_t10 VDDIO_t6 136.519
R1045 VDDIO_t6 VDDIO_t12 136.519
R1046 VDDIO_t12 VDDIO_t14 136.519
R1047 VDDIO_t14 VDDIO_t16 136.519
R1048 VDDIO_t16 VDDIO_t22 136.519
R1049 VDDIO_t22 VDDIO_t24 136.519
R1050 VDDIO_t24 VDDIO_t18 136.519
R1051 VDDIO_t18 VDDIO_t20 136.519
R1052 VDDIO_t20 VDDIO_t26 136.519
R1053 VDDIO_t26 VDDIO_t28 136.519
R1054 VDDIO_t28 VDDIO_t30 136.519
R1055 VDDIO_t30 VDDIO_t40 136.519
R1056 VDDIO_t40 VDDIO_t38 136.519
R1057 VDDIO_t38 VDDIO_t42 136.519
R1058 VDDIO_t42 VDDIO_t48 136.519
R1059 VDDIO_t48 VDDIO_t46 136.519
R1060 VDDIO_t46 VDDIO_t44 136.519
R1061 VDDIO_t44 VDDIO_t34 136.519
R1062 VDDIO_t34 VDDIO_t50 136.519
R1063 VDDIO_t50 VDDIO_t52 136.519
R1064 VDDIO_t52 VDDIO_t54 136.519
R1065 VDDIO_t54 VDDIO_t56 136.519
R1066 VDDIO_t56 VDDIO_t60 136.519
R1067 VDDIO_t60 VDDIO_t58 136.519
R1068 VDDIO_t58 VDDIO_t36 136.519
R1069 VDDIO_t36 VDDIO_t62 136.519
R1070 VDDIO_t62 VDDIO_t64 136.519
R1071 VDDIO_t64 VDDIO_t66 136.519
R1072 VDDIO_t66 VDDIO_t72 136.519
R1073 VDDIO_t72 VDDIO_t70 136.519
R1074 VDDIO_t70 VDDIO_t68 136.519
R1075 VDDIO_t68 VDDIO_t32 136.519
R1076 VDDIO_t32 VDDIO_t74 136.519
R1077 VDDIO_t74 VDDIO_t76 136.519
R1078 VDDIO_t76 VDDIO_t78 136.519
R1079 VDDIO_n50 VDDIO_n49 14.0765
R1080 VDDIO_n64 VDDIO_n63 10.7074
R1081 VDDIO_n65 VDDIO_n64 8.4605
R1082 VDDIO_n20 VDDIO_t79 7.27651
R1083 VDDIO_n20 VDDIO_n19 6.55251
R1084 VDDIO_n21 VDDIO_n18 6.55251
R1085 VDDIO_n22 VDDIO_n17 6.55251
R1086 VDDIO_n23 VDDIO_n16 6.55251
R1087 VDDIO_n24 VDDIO_n15 6.55251
R1088 VDDIO_n25 VDDIO_n14 6.55251
R1089 VDDIO_n26 VDDIO_n13 6.55251
R1090 VDDIO_n51 VDDIO_n12 6.55251
R1091 VDDIO_n52 VDDIO_n11 6.55251
R1092 VDDIO_n53 VDDIO_n10 6.55251
R1093 VDDIO_n54 VDDIO_n9 6.55251
R1094 VDDIO_n55 VDDIO_n8 6.55251
R1095 VDDIO_n56 VDDIO_n7 6.55251
R1096 VDDIO_n57 VDDIO_n6 6.55251
R1097 VDDIO_n58 VDDIO_n5 6.55251
R1098 VDDIO_n59 VDDIO_n4 6.55251
R1099 VDDIO_n60 VDDIO_n3 6.55251
R1100 VDDIO_n61 VDDIO_n2 6.55251
R1101 VDDIO_n62 VDDIO_n1 6.55251
R1102 VDDIO_n63 VDDIO_n0 5.80076
R1103 VDDIO VDDIO_n66 5.58476
R1104 VDDIO_n64 VDDIO 4.9355
R1105 VDDIO_n65 VDDIO 4.9355
R1106 VDDIO_n27 VDDIO_t97 3.0835
R1107 VDDIO_n42 VDDIO_t83 2.9755
R1108 VDDIO_n44 VDDIO_t86 2.9755
R1109 VDDIO_n46 VDDIO_t105 2.9755
R1110 VDDIO_n48 VDDIO_t109 2.9755
R1111 VDDIO_n40 VDDIO_t90 2.9755
R1112 VDDIO_n37 VDDIO_t92 2.9755
R1113 VDDIO_n35 VDDIO_t107 2.9755
R1114 VDDIO_n33 VDDIO_t88 2.9755
R1115 VDDIO_n31 VDDIO_t81 2.9755
R1116 VDDIO_n28 VDDIO_t95 2.9755
R1117 VDDIO_n66 VDDIO_t103 1.21208
R1118 VDDIO_n0 VDDIO_t1 1.1095
R1119 VDDIO VDDIO_n65 1.0805
R1120 VDDIO_n39 VDDIO_n38 0.5855
R1121 VDDIO_n30 VDDIO_n29 0.5855
R1122 VDDIO_n43 VDDIO_n42 0.4925
R1123 VDDIO_n45 VDDIO_n44 0.4925
R1124 VDDIO_n37 VDDIO_n36 0.4925
R1125 VDDIO_n35 VDDIO_n34 0.4925
R1126 VDDIO_n33 VDDIO_n32 0.4925
R1127 VDDIO_n28 VDDIO_n27 0.4925
R1128 VDDIO_n49 VDDIO_n41 0.4325
R1129 VDDIO_n19 VDDIO_t75 0.3645
R1130 VDDIO_n19 VDDIO_t77 0.3645
R1131 VDDIO_n18 VDDIO_t69 0.3645
R1132 VDDIO_n18 VDDIO_t33 0.3645
R1133 VDDIO_n17 VDDIO_t73 0.3645
R1134 VDDIO_n17 VDDIO_t71 0.3645
R1135 VDDIO_n16 VDDIO_t65 0.3645
R1136 VDDIO_n16 VDDIO_t67 0.3645
R1137 VDDIO_n15 VDDIO_t37 0.3645
R1138 VDDIO_n15 VDDIO_t63 0.3645
R1139 VDDIO_n14 VDDIO_t61 0.3645
R1140 VDDIO_n14 VDDIO_t59 0.3645
R1141 VDDIO_n13 VDDIO_t55 0.3645
R1142 VDDIO_n13 VDDIO_t57 0.3645
R1143 VDDIO_n12 VDDIO_t51 0.3645
R1144 VDDIO_n12 VDDIO_t53 0.3645
R1145 VDDIO_n11 VDDIO_t45 0.3645
R1146 VDDIO_n11 VDDIO_t35 0.3645
R1147 VDDIO_n10 VDDIO_t49 0.3645
R1148 VDDIO_n10 VDDIO_t47 0.3645
R1149 VDDIO_n9 VDDIO_t39 0.3645
R1150 VDDIO_n9 VDDIO_t43 0.3645
R1151 VDDIO_n8 VDDIO_t31 0.3645
R1152 VDDIO_n8 VDDIO_t41 0.3645
R1153 VDDIO_n7 VDDIO_t27 0.3645
R1154 VDDIO_n7 VDDIO_t29 0.3645
R1155 VDDIO_n6 VDDIO_t19 0.3645
R1156 VDDIO_n6 VDDIO_t21 0.3645
R1157 VDDIO_n5 VDDIO_t23 0.3645
R1158 VDDIO_n5 VDDIO_t25 0.3645
R1159 VDDIO_n4 VDDIO_t15 0.3645
R1160 VDDIO_n4 VDDIO_t17 0.3645
R1161 VDDIO_n3 VDDIO_t7 0.3645
R1162 VDDIO_n3 VDDIO_t13 0.3645
R1163 VDDIO_n2 VDDIO_t5 0.3645
R1164 VDDIO_n2 VDDIO_t11 0.3645
R1165 VDDIO_n1 VDDIO_t3 0.3645
R1166 VDDIO_n1 VDDIO_t9 0.3645
R1167 VDDIO_n62 VDDIO_n61 0.3605
R1168 VDDIO_n61 VDDIO_n60 0.3605
R1169 VDDIO_n60 VDDIO_n59 0.3605
R1170 VDDIO_n59 VDDIO_n58 0.3605
R1171 VDDIO_n58 VDDIO_n57 0.3605
R1172 VDDIO_n57 VDDIO_n56 0.3605
R1173 VDDIO_n56 VDDIO_n55 0.3605
R1174 VDDIO_n55 VDDIO_n54 0.3605
R1175 VDDIO_n54 VDDIO_n53 0.3605
R1176 VDDIO_n53 VDDIO_n52 0.3605
R1177 VDDIO_n52 VDDIO_n51 0.3605
R1178 VDDIO_n26 VDDIO_n25 0.3605
R1179 VDDIO_n25 VDDIO_n24 0.3605
R1180 VDDIO_n24 VDDIO_n23 0.3605
R1181 VDDIO_n23 VDDIO_n22 0.3605
R1182 VDDIO_n22 VDDIO_n21 0.3605
R1183 VDDIO_n21 VDDIO_n20 0.3605
R1184 VDDIO_n47 VDDIO_n46 0.3575
R1185 VDDIO_n40 VDDIO_n39 0.3575
R1186 VDDIO_n31 VDDIO_n30 0.3575
R1187 VDDIO VDDIO_n62 0.345535
R1188 VDDIO_n50 VDDIO_n26 0.221
R1189 VDDIO_n51 VDDIO_n50 0.14
R1190 VDDIO_n44 VDDIO_n43 0.1085
R1191 VDDIO_n46 VDDIO_n45 0.1085
R1192 VDDIO_n48 VDDIO_n47 0.1085
R1193 VDDIO_n41 VDDIO_n40 0.1085
R1194 VDDIO_n38 VDDIO_n37 0.1085
R1195 VDDIO_n36 VDDIO_n35 0.1085
R1196 VDDIO_n34 VDDIO_n33 0.1085
R1197 VDDIO_n32 VDDIO_n31 0.1085
R1198 VDDIO_n29 VDDIO_n28 0.1085
R1199 VDDIO_n49 VDDIO_n48 0.0455
R1200 VDDIO_n63 VDDIO 0.00259302
R1201 a_n7856_9000_n20 a_n7856_9000_t80 15.6427
R1202 a_n7856_9000_n39 a_n7856_9000_n0 6.66725
R1203 a_n7856_9000_n38 a_n7856_9000_n1 6.66725
R1204 a_n7856_9000_n37 a_n7856_9000_n2 6.66725
R1205 a_n7856_9000_n36 a_n7856_9000_n3 6.66725
R1206 a_n7856_9000_n35 a_n7856_9000_n4 6.66725
R1207 a_n7856_9000_n34 a_n7856_9000_n5 6.66725
R1208 a_n7856_9000_n33 a_n7856_9000_n6 6.66725
R1209 a_n7856_9000_n32 a_n7856_9000_n7 6.66725
R1210 a_n7856_9000_n31 a_n7856_9000_n8 6.66725
R1211 a_n7856_9000_n30 a_n7856_9000_n9 6.66725
R1212 a_n7856_9000_n29 a_n7856_9000_n10 6.66725
R1213 a_n7856_9000_n28 a_n7856_9000_n11 6.66725
R1214 a_n7856_9000_n27 a_n7856_9000_n12 6.66725
R1215 a_n7856_9000_n26 a_n7856_9000_n13 6.66725
R1216 a_n7856_9000_n25 a_n7856_9000_n14 6.66725
R1217 a_n7856_9000_n24 a_n7856_9000_n15 6.66725
R1218 a_n7856_9000_n23 a_n7856_9000_n16 6.66725
R1219 a_n7856_9000_n22 a_n7856_9000_n17 6.66725
R1220 a_n7856_9000_n21 a_n7856_9000_n18 6.66725
R1221 a_n7856_9000_n20 a_n7856_9000_n19 6.66725
R1222 a_n7856_9000_n59 a_n7856_9000_n58 6.34065
R1223 a_n7856_9000_n78 a_n7856_9000_n77 6.00576
R1224 a_n7856_9000_n59 a_n7856_9000_n57 6.00576
R1225 a_n7856_9000_n60 a_n7856_9000_n56 6.00576
R1226 a_n7856_9000_n61 a_n7856_9000_n55 6.00576
R1227 a_n7856_9000_n62 a_n7856_9000_n54 6.00576
R1228 a_n7856_9000_n63 a_n7856_9000_n53 6.00576
R1229 a_n7856_9000_n64 a_n7856_9000_n52 6.00576
R1230 a_n7856_9000_n65 a_n7856_9000_n51 6.00576
R1231 a_n7856_9000_n66 a_n7856_9000_n50 6.00576
R1232 a_n7856_9000_n67 a_n7856_9000_n49 6.00576
R1233 a_n7856_9000_n68 a_n7856_9000_n48 6.00576
R1234 a_n7856_9000_n69 a_n7856_9000_n47 6.00576
R1235 a_n7856_9000_n70 a_n7856_9000_n46 6.00576
R1236 a_n7856_9000_n71 a_n7856_9000_n45 6.00576
R1237 a_n7856_9000_n72 a_n7856_9000_n44 6.00576
R1238 a_n7856_9000_n73 a_n7856_9000_n43 6.00576
R1239 a_n7856_9000_n74 a_n7856_9000_n42 6.00576
R1240 a_n7856_9000_n75 a_n7856_9000_n41 6.00576
R1241 a_n7856_9000_n76 a_n7856_9000_n40 6.00576
R1242 a_n7856_9000_n77 a_n7856_9000_n39 2.08681
R1243 a_n7856_9000_n0 a_n7856_9000_t40 0.8195
R1244 a_n7856_9000_n0 a_n7856_9000_t41 0.8195
R1245 a_n7856_9000_n1 a_n7856_9000_t42 0.8195
R1246 a_n7856_9000_n1 a_n7856_9000_t43 0.8195
R1247 a_n7856_9000_n2 a_n7856_9000_t44 0.8195
R1248 a_n7856_9000_n2 a_n7856_9000_t45 0.8195
R1249 a_n7856_9000_n3 a_n7856_9000_t46 0.8195
R1250 a_n7856_9000_n3 a_n7856_9000_t47 0.8195
R1251 a_n7856_9000_n4 a_n7856_9000_t48 0.8195
R1252 a_n7856_9000_n4 a_n7856_9000_t49 0.8195
R1253 a_n7856_9000_n5 a_n7856_9000_t50 0.8195
R1254 a_n7856_9000_n5 a_n7856_9000_t51 0.8195
R1255 a_n7856_9000_n6 a_n7856_9000_t52 0.8195
R1256 a_n7856_9000_n6 a_n7856_9000_t53 0.8195
R1257 a_n7856_9000_n7 a_n7856_9000_t54 0.8195
R1258 a_n7856_9000_n7 a_n7856_9000_t55 0.8195
R1259 a_n7856_9000_n8 a_n7856_9000_t56 0.8195
R1260 a_n7856_9000_n8 a_n7856_9000_t57 0.8195
R1261 a_n7856_9000_n9 a_n7856_9000_t58 0.8195
R1262 a_n7856_9000_n9 a_n7856_9000_t59 0.8195
R1263 a_n7856_9000_n10 a_n7856_9000_t60 0.8195
R1264 a_n7856_9000_n10 a_n7856_9000_t61 0.8195
R1265 a_n7856_9000_n11 a_n7856_9000_t62 0.8195
R1266 a_n7856_9000_n11 a_n7856_9000_t63 0.8195
R1267 a_n7856_9000_n12 a_n7856_9000_t64 0.8195
R1268 a_n7856_9000_n12 a_n7856_9000_t65 0.8195
R1269 a_n7856_9000_n13 a_n7856_9000_t66 0.8195
R1270 a_n7856_9000_n13 a_n7856_9000_t67 0.8195
R1271 a_n7856_9000_n14 a_n7856_9000_t68 0.8195
R1272 a_n7856_9000_n14 a_n7856_9000_t69 0.8195
R1273 a_n7856_9000_n15 a_n7856_9000_t70 0.8195
R1274 a_n7856_9000_n15 a_n7856_9000_t71 0.8195
R1275 a_n7856_9000_n16 a_n7856_9000_t72 0.8195
R1276 a_n7856_9000_n16 a_n7856_9000_t73 0.8195
R1277 a_n7856_9000_n17 a_n7856_9000_t74 0.8195
R1278 a_n7856_9000_n17 a_n7856_9000_t75 0.8195
R1279 a_n7856_9000_n18 a_n7856_9000_t76 0.8195
R1280 a_n7856_9000_n18 a_n7856_9000_t77 0.8195
R1281 a_n7856_9000_n19 a_n7856_9000_t78 0.8195
R1282 a_n7856_9000_n19 a_n7856_9000_t79 0.8195
R1283 a_n7856_9000_n78 a_n7856_9000_t38 0.3645
R1284 a_n7856_9000_t39 a_n7856_9000_n78 0.3645
R1285 a_n7856_9000_n58 a_n7856_9000_t0 0.3645
R1286 a_n7856_9000_n58 a_n7856_9000_t1 0.3645
R1287 a_n7856_9000_n57 a_n7856_9000_t2 0.3645
R1288 a_n7856_9000_n57 a_n7856_9000_t3 0.3645
R1289 a_n7856_9000_n56 a_n7856_9000_t4 0.3645
R1290 a_n7856_9000_n56 a_n7856_9000_t5 0.3645
R1291 a_n7856_9000_n55 a_n7856_9000_t6 0.3645
R1292 a_n7856_9000_n55 a_n7856_9000_t7 0.3645
R1293 a_n7856_9000_n54 a_n7856_9000_t8 0.3645
R1294 a_n7856_9000_n54 a_n7856_9000_t9 0.3645
R1295 a_n7856_9000_n53 a_n7856_9000_t10 0.3645
R1296 a_n7856_9000_n53 a_n7856_9000_t11 0.3645
R1297 a_n7856_9000_n52 a_n7856_9000_t12 0.3645
R1298 a_n7856_9000_n52 a_n7856_9000_t13 0.3645
R1299 a_n7856_9000_n51 a_n7856_9000_t14 0.3645
R1300 a_n7856_9000_n51 a_n7856_9000_t15 0.3645
R1301 a_n7856_9000_n50 a_n7856_9000_t16 0.3645
R1302 a_n7856_9000_n50 a_n7856_9000_t17 0.3645
R1303 a_n7856_9000_n49 a_n7856_9000_t18 0.3645
R1304 a_n7856_9000_n49 a_n7856_9000_t19 0.3645
R1305 a_n7856_9000_n48 a_n7856_9000_t20 0.3645
R1306 a_n7856_9000_n48 a_n7856_9000_t21 0.3645
R1307 a_n7856_9000_n47 a_n7856_9000_t22 0.3645
R1308 a_n7856_9000_n47 a_n7856_9000_t23 0.3645
R1309 a_n7856_9000_n46 a_n7856_9000_t24 0.3645
R1310 a_n7856_9000_n46 a_n7856_9000_t25 0.3645
R1311 a_n7856_9000_n45 a_n7856_9000_t26 0.3645
R1312 a_n7856_9000_n45 a_n7856_9000_t27 0.3645
R1313 a_n7856_9000_n44 a_n7856_9000_t28 0.3645
R1314 a_n7856_9000_n44 a_n7856_9000_t29 0.3645
R1315 a_n7856_9000_n43 a_n7856_9000_t30 0.3645
R1316 a_n7856_9000_n43 a_n7856_9000_t31 0.3645
R1317 a_n7856_9000_n42 a_n7856_9000_t32 0.3645
R1318 a_n7856_9000_n42 a_n7856_9000_t33 0.3645
R1319 a_n7856_9000_n41 a_n7856_9000_t34 0.3645
R1320 a_n7856_9000_n41 a_n7856_9000_t35 0.3645
R1321 a_n7856_9000_n40 a_n7856_9000_t36 0.3645
R1322 a_n7856_9000_n40 a_n7856_9000_t37 0.3645
R1323 a_n7856_9000_n60 a_n7856_9000_n59 0.335384
R1324 a_n7856_9000_n61 a_n7856_9000_n60 0.335384
R1325 a_n7856_9000_n62 a_n7856_9000_n61 0.335384
R1326 a_n7856_9000_n63 a_n7856_9000_n62 0.335384
R1327 a_n7856_9000_n64 a_n7856_9000_n63 0.335384
R1328 a_n7856_9000_n65 a_n7856_9000_n64 0.335384
R1329 a_n7856_9000_n66 a_n7856_9000_n65 0.335384
R1330 a_n7856_9000_n67 a_n7856_9000_n66 0.335384
R1331 a_n7856_9000_n68 a_n7856_9000_n67 0.335384
R1332 a_n7856_9000_n69 a_n7856_9000_n68 0.335384
R1333 a_n7856_9000_n70 a_n7856_9000_n69 0.335384
R1334 a_n7856_9000_n71 a_n7856_9000_n70 0.335384
R1335 a_n7856_9000_n72 a_n7856_9000_n71 0.335384
R1336 a_n7856_9000_n73 a_n7856_9000_n72 0.335384
R1337 a_n7856_9000_n74 a_n7856_9000_n73 0.335384
R1338 a_n7856_9000_n75 a_n7856_9000_n74 0.335384
R1339 a_n7856_9000_n76 a_n7856_9000_n75 0.335384
R1340 a_n7856_9000_n77 a_n7856_9000_n76 0.335384
R1341 a_n7856_9000_n39 a_n7856_9000_n38 0.253132
R1342 a_n7856_9000_n38 a_n7856_9000_n37 0.253132
R1343 a_n7856_9000_n37 a_n7856_9000_n36 0.253132
R1344 a_n7856_9000_n36 a_n7856_9000_n35 0.253132
R1345 a_n7856_9000_n35 a_n7856_9000_n34 0.253132
R1346 a_n7856_9000_n34 a_n7856_9000_n33 0.253132
R1347 a_n7856_9000_n33 a_n7856_9000_n32 0.253132
R1348 a_n7856_9000_n32 a_n7856_9000_n31 0.253132
R1349 a_n7856_9000_n31 a_n7856_9000_n30 0.253132
R1350 a_n7856_9000_n30 a_n7856_9000_n29 0.253132
R1351 a_n7856_9000_n29 a_n7856_9000_n28 0.253132
R1352 a_n7856_9000_n28 a_n7856_9000_n27 0.253132
R1353 a_n7856_9000_n27 a_n7856_9000_n26 0.253132
R1354 a_n7856_9000_n26 a_n7856_9000_n25 0.253132
R1355 a_n7856_9000_n25 a_n7856_9000_n24 0.253132
R1356 a_n7856_9000_n24 a_n7856_9000_n23 0.253132
R1357 a_n7856_9000_n23 a_n7856_9000_n22 0.253132
R1358 a_n7856_9000_n22 a_n7856_9000_n21 0.253132
R1359 a_n7856_9000_n21 a_n7856_9000_n20 0.253132
R1360 a_628_11080_t0 a_628_11080_t1 6.08195
R1361 a_n3172_11080_t0 a_n3172_11080_t1 6.08195
R1362 a_n4804_11920_t0 a_n4804_11920_t1 10.5985
R1363 a_2028_11080_t3 a_2028_11080_t2 96.4648
R1364 a_2028_11080_n0 a_2028_11080_t3 56.8672
R1365 a_2028_11080_n0 a_2028_11080_t1 5.15205
R1366 a_2028_11080_t0 a_2028_11080_n0 2.69247
R1367 a_628_11920_t4 a_628_11920_t3 96.4648
R1368 a_628_11920_n0 a_628_11920_t4 51.971
R1369 a_628_11920_n0 a_628_11920_t2 9.50876
R1370 a_628_11920_n1 a_628_11920_n0 5.063
R1371 a_628_11920_n1 a_628_11920_t1 4.87376
R1372 a_628_11920_t0 a_628_11920_n1 2.97195
R1373 a_n972_11080_t3 a_n972_11080_t2 96.4648
R1374 a_n972_11080_n0 a_n972_11080_t3 55.4272
R1375 a_n972_11080_n0 a_n972_11080_t0 5.15205
R1376 a_n972_11080_t1 a_n972_11080_n0 2.69247
R1377 a_n1772_11080_t3 a_n1772_11080_t2 96.4648
R1378 a_n1772_11080_n0 a_n1772_11080_t3 54.9472
R1379 a_n1772_11080_n0 a_n1772_11080_t1 5.15205
R1380 a_n1772_11080_t0 a_n1772_11080_n0 2.69247
R1381 a_n3172_11920_t4 a_n3172_11920_t3 96.4648
R1382 a_n3172_11920_n0 a_n3172_11920_t4 50.051
R1383 a_n3172_11920_n0 a_n3172_11920_t2 9.50876
R1384 a_n3172_11920_n1 a_n3172_11920_n0 5.063
R1385 a_n3172_11920_n1 a_n3172_11920_t1 4.87376
R1386 a_n3172_11920_t0 a_n3172_11920_n1 2.97195
R1387 a_n6172_11080_t3 a_n6172_11080_t2 96.4648
R1388 a_n6172_11080_n0 a_n6172_11080_t3 55.5652
R1389 a_n6172_11080_n0 a_n6172_11080_t0 5.15205
R1390 a_n6172_11080_t1 a_n6172_11080_n0 2.69247
R1391 a_n4948_11920_t6 a_n4948_11920_t4 96.4648
R1392 a_n4948_11920_t5 a_n4948_11920_t3 96.4648
R1393 a_n4948_11920_n0 a_n4948_11920_t5 45.179
R1394 a_n4948_11920_n0 a_n4948_11920_t6 41.759
R1395 a_n4948_11920_n2 a_n4948_11920_t0 10.1312
R1396 a_n4948_11920_n1 a_n4948_11920_n0 7.8772
R1397 a_n4948_11920_n1 a_n4948_11920_t2 7.09797
R1398 a_n4948_11920_t1 a_n4948_11920_n2 7.09797
R1399 a_n4948_11920_n2 a_n4948_11920_n1 0.607022
R1400 a_n5372_11080_t3 a_n5372_11080_t2 119.407
R1401 a_n5372_11080_n0 a_n5372_11080_t3 53.8564
R1402 a_n5372_11080_n0 a_n5372_11080_t0 5.15205
R1403 a_n5372_11080_t1 a_n5372_11080_n0 2.69247
C0 GP VDDIO 7.34963f
C1 PAD VSSIO 0.19476p
C2 GN VSSIO 12.22038f
C3 GP VSSIO 8.30949f
C4 PU_OK VSSIO 4.38433f
C5 OE_N VSSIO 4.52714f
C6 OUT VSSIO 5.80163f
C7 VDDIO VSSIO 85.85404f
C8 VDDIO_t98 VSSIO 2.96988f
C9 OUT_n0 VSSIO 2.73011f
C10 GP_n39 VSSIO 2.06022f
.ends
