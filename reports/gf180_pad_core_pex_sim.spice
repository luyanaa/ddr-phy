* SPICE3 file created from gf180_pad_core_flat.ext - technology: gf180mcuD

.subckt gf180_pad_core_flat GP GN PAD VSSIO VDDIO IN OUT OE_N PU_OK
X0 VSSIO_t227 GN_t2 a_n7856_9000_t39 VSSIO_t226 nfet_03v3 ad=35.2n pd=0.976m as=20.8n ps=0.504m w=2e-06 l=2.8e-07
X1 a_n7856_9000_t56 GP_t25 VDDIO_t53 VDDIO_t52 pfet_03v3 ad=52n pd=1.104m as=52n ps=1.104m w=5e-06 l=2.8e-07
X2 VSSIO_t89 VSSIO_t87 PAD_t21 VSSIO_t88 nfet_03v3 ad=41.6n pd=0.904m as=41.6n ps=0.904m w=4e-06 l=2.8e-07
X3 a_n7856_9000_t16 GN_t25 VSSIO_t179 VSSIO_t178 nfet_03v3 ad=20.8n pd=0.504m as=20.8n ps=0.504m w=2e-06 l=2.8e-07
X4 VDDIO_t97 GP_t2 a_n7856_9000_t79 VDDIO_t96 pfet_03v3 ad=88n pd=2.176m as=52n ps=1.104m w=5e-06 l=2.8e-07
X5 VSSIO_t71 VSSIO_t69 PAD_t18 VSSIO_t70 nfet_03v3 ad=41.6n pd=0.904m as=41.6n ps=0.904m w=4e-06 l=2.8e-07
X6 VDDIO_t39 GP_t32 a_n7856_9000_t49 VDDIO_t38 pfet_03v3 ad=52n pd=1.104m as=52n ps=1.104m w=5e-06 l=2.8e-07
X7 a_n4804_11920_t1 PU_OK_t1 a_n4948_11920_t1 VSSIO_t228 nfet_03v3 ad=17.6n pd=0.576m as=17.6n ps=0.576m w=1e-06 l=2.8e-07
X8 a_n3172_11920_t1 a_n6172_11080_t2 a_n3172_11080_t1 VDDIO_t2 pfet_03v3 ad=35.2n pd=0.976m as=35.2n ps=0.976m w=2e-06 l=2.8e-07
X9 PAD_t11 VSSIO_t78 VSSIO_t80 VSSIO_t79 nfet_03v3 ad=41.6n pd=0.904m as=41.6n ps=0.904m w=4e-06 l=2.8e-07
X10 VSSIO_t197 GN_t18 a_n7856_9000_t23 VSSIO_t196 nfet_03v3 ad=20.8n pd=0.504m as=20.8n ps=0.504m w=2e-06 l=2.8e-07
X11 a_n7856_9000_t72 GP_t9 VDDIO_t85 VDDIO_t84 pfet_03v3 ad=52n pd=1.104m as=52n ps=1.104m w=5e-06 l=2.8e-07
X12 a_n7856_9000_t50 GP_t31 VDDIO_t41 VDDIO_t40 pfet_03v3 ad=52n pd=1.104m as=52n ps=1.104m w=5e-06 l=2.8e-07
X13 VSSIO_t53 VSSIO_t51 PAD_t27 VSSIO_t52 nfet_03v3 ad=41.6n pd=0.904m as=41.6n ps=0.904m w=4e-06 l=2.8e-07
X14 VSSIO_t145 a_n5372_11080_t3 a_n4804_11920_t0 VSSIO_t144 nfet_03v3 ad=17.6n pd=0.576m as=17.6n ps=0.576m w=1e-06 l=2.8e-07
X15 VSSIO_t203 GN_t16 a_n7856_9000_t25 VSSIO_t202 nfet_03v3 ad=20.8n pd=0.504m as=20.8n ps=0.504m w=2e-06 l=2.8e-07
X16 a_n3172_11920_t2 a_n6172_11080_t3 VSSIO_t141 VSSIO_t140 nfet_03v3 ad=17.6n pd=0.576m as=17.6n ps=0.576m w=1e-06 l=2.8e-07
X17 a_n7856_9000_t42 GP_t39 VDDIO_t25 VDDIO_t24 pfet_03v3 ad=52n pd=1.104m as=52n ps=1.104m w=5e-06 l=2.8e-07
X18 PAD_t12 VSSIO_t60 VSSIO_t62 VSSIO_t61 nfet_03v3 ad=41.6n pd=0.904m as=41.6n ps=0.904m w=4e-06 l=2.8e-07
X19 a_n7856_9000_t22 GN_t19 VSSIO_t201 VSSIO_t200 nfet_03v3 ad=20.8n pd=0.504m as=20.8n ps=0.504m w=2e-06 l=2.8e-07
X20 VDDIO_t91 GP_t8 a_n7856_9000_t73 VDDIO_t90 pfet_03v3 ad=52n pd=1.104m as=52n ps=1.104m w=5e-06 l=2.8e-07
X21 a_n7856_9000_t30 GN_t11 VSSIO_t209 VSSIO_t208 nfet_03v3 ad=20.8n pd=0.504m as=20.8n ps=0.504m w=2e-06 l=2.8e-07
X22 a_n972_11080_t0 a_n1772_11080_t2 VDDIO_t101 VDDIO_t100 pfet_03v3 ad=35.2n pd=0.976m as=35.2n ps=0.976m w=2e-06 l=2.8e-07
X23 PAD_t24 VSSIO_t102 VSSIO_t104 VSSIO_t103 nfet_03v3 ad=41.6n pd=0.904m as=41.6n ps=0.904m w=4e-06 l=2.8e-07
X24 VDDIO_t23 GP_t38 a_n7856_9000_t43 VDDIO_t22 pfet_03v3 ad=52n pd=1.104m as=52n ps=1.104m w=5e-06 l=2.8e-07
X25 PAD_t6 VSSIO_t12 VSSIO_t14 VSSIO_t13 nfet_03v3 ad=41.6n pd=0.904m as=41.6n ps=0.904m w=4e-06 l=2.8e-07
X26 a_n972_11080_t1 a_n1772_11080_t3 VSSIO_t231 VSSIO_t230 nfet_03v3 ad=17.6n pd=0.576m as=17.6n ps=0.576m w=1e-06 l=2.8e-07
X27 VSSIO_t185 GN_t12 a_n7856_9000_t29 VSSIO_t184 nfet_03v3 ad=20.8n pd=0.504m as=20.8n ps=0.504m w=2e-06 l=2.8e-07
X28 a_n7856_9000_t66 GP_t15 VDDIO_t79 VDDIO_t78 pfet_03v3 ad=52n pd=1.104m as=52n ps=1.104m w=5e-06 l=2.8e-07
X29 PAD_t38 VSSIO_t84 VSSIO_t86 VSSIO_t85 nfet_03v3 ad=41.6n pd=0.904m as=41.6n ps=0.904m w=4e-06 l=2.8e-07
X30 VSSIO_t211 GN_t10 a_n7856_9000_t31 VSSIO_t210 nfet_03v3 ad=20.8n pd=0.504m as=20.8n ps=0.504m w=2e-06 l=2.8e-07
X31 a_n7856_9000_t64 GP_t17 VDDIO_t69 VDDIO_t68 pfet_03v3 ad=52n pd=1.104m as=52n ps=1.104m w=5e-06 l=2.8e-07
D0 VSSIO_t232 VDDIO_t102 diode_pd2nw_03v3 pj=4e-05 area=1e-10
X32 VSSIO_t157 GN_t38 a_n7856_9000_t3 VSSIO_t156 nfet_03v3 ad=20.8n pd=0.504m as=20.8n ps=0.504m w=2e-06 l=2.8e-07
D1 VSSIO_t128 PAD_t44 diode_nd2ps_03v3 pj=3.2e-05 area=6.4e-11
X33 VSSIO_t95 VSSIO_t93 PAD_t32 VSSIO_t94 nfet_03v3 ad=41.6n pd=0.904m as=41.6n ps=0.904m w=4e-06 l=2.8e-07
X34 VSSIO_t29 VSSIO_t27 PAD_t5 VSSIO_t28 nfet_03v3 ad=41.6n pd=0.904m as=41.6n ps=0.904m w=4e-06 l=2.8e-07
X35 a_n7856_9000_t8 GN_t33 VSSIO_t165 VSSIO_t164 nfet_03v3 ad=20.8n pd=0.504m as=20.8n ps=0.504m w=2e-06 l=2.8e-07
X36 a_n7856_9000_t2 GN_t39 VSSIO_t153 VSSIO_t152 nfet_03v3 ad=20.8n pd=0.504m as=20.8n ps=0.504m w=2e-06 l=2.8e-07
X37 PAD_t15 VSSIO_t66 VSSIO_t68 VSSIO_t67 nfet_03v3 ad=41.6n pd=0.904m as=41.6n ps=0.904m w=4e-06 l=2.8e-07
X38 a_n7856_9000_t36 GN_t5 VSSIO_t221 VSSIO_t220 nfet_03v3 ad=20.8n pd=0.504m as=20.8n ps=0.504m w=2e-06 l=2.8e-07
X39 VDDIO_t57 GP_t22 a_n7856_9000_t59 VDDIO_t56 pfet_03v3 ad=52n pd=1.104m as=52n ps=1.104m w=5e-06 l=2.8e-07
X40 a_n7856_9000_t38 GN_t3 VSSIO_t223 VSSIO_t222 nfet_03v3 ad=20.8n pd=0.504m as=20.8n ps=0.504m w=2e-06 l=2.8e-07
X41 VSSIO_t155 GN_t34 a_n7856_9000_t7 VSSIO_t154 nfet_03v3 ad=20.8n pd=0.504m as=20.8n ps=0.504m w=2e-06 l=2.8e-07
X42 VDDIO_t51 GP_t24 a_n7856_9000_t57 VDDIO_t50 pfet_03v3 ad=52n pd=1.104m as=52n ps=1.104m w=5e-06 l=2.8e-07
X43 VSSIO_t77 VSSIO_t75 PAD_t35 VSSIO_t76 nfet_03v3 ad=41.6n pd=0.904m as=41.6n ps=0.904m w=4e-06 l=2.8e-07
X44 a_n7856_9000_t60 GP_t21 VDDIO_t65 VDDIO_t64 pfet_03v3 ad=52n pd=1.104m as=52n ps=1.104m w=5e-06 l=2.8e-07
X45 VSSIO_t225 GN_t4 a_n7856_9000_t37 VSSIO_t224 nfet_03v3 ad=20.8n pd=0.504m as=20.8n ps=0.504m w=2e-06 l=2.8e-07
X46 VSSIO_t183 GN_t26 a_n7856_9000_t15 VSSIO_t182 nfet_03v3 ad=20.8n pd=0.504m as=20.8n ps=0.504m w=2e-06 l=2.8e-07
X47 VSSIO_t119 VSSIO_t117 PAD_t33 VSSIO_t118 nfet_03v3 ad=41.6n pd=0.904m as=41.6n ps=0.904m w=4e-06 l=2.8e-07
X48 IN_t1 PAD_t42 VSSIO_t133 VSSIO_t132 nfet_03v3 ad=35.2n pd=0.976m as=35.2n ps=0.976m w=2e-06 l=2.8e-07
X49 a_n7856_9000_t58 GP_t23 VDDIO_t55 VDDIO_t54 pfet_03v3 ad=52n pd=1.104m as=52n ps=1.104m w=5e-06 l=2.8e-07
X50 a_n7856_9000_t52 GP_t29 VDDIO_t43 VDDIO_t42 pfet_03v3 ad=52n pd=1.104m as=52n ps=1.104m w=5e-06 l=2.8e-07
X51 a_n7856_9000_t14 GN_t27 VSSIO_t177 VSSIO_t176 nfet_03v3 ad=20.8n pd=0.504m as=20.8n ps=0.504m w=2e-06 l=2.8e-07
X52 VSSIO_t101 VSSIO_t99 PAD_t37 VSSIO_t100 nfet_03v3 ad=41.6n pd=0.904m as=41.6n ps=0.904m w=4e-06 l=2.8e-07
X53 VDDIO_t45 GP_t28 a_n7856_9000_t53 VDDIO_t44 pfet_03v3 ad=52n pd=1.104m as=52n ps=1.104m w=5e-06 l=2.8e-07
X54 VSSIO_t11 VSSIO_t9 PAD_t8 VSSIO_t10 nfet_03v3 ad=41.6n pd=0.904m as=41.6n ps=0.904m w=4e-06 l=2.8e-07
X55 VDDIO_t37 GP_t30 a_n7856_9000_t51 VDDIO_t36 pfet_03v3 ad=52n pd=1.104m as=52n ps=1.104m w=5e-06 l=2.8e-07
X56 PAD_t36 VSSIO_t108 VSSIO_t110 VSSIO_t109 nfet_03v3 ad=41.6n pd=0.904m as=41.6n ps=0.904m w=4e-06 l=2.8e-07
X57 PAD_t9 VSSIO_t18 VSSIO_t20 VSSIO_t19 nfet_03v3 ad=41.6n pd=0.904m as=41.6n ps=0.904m w=4e-06 l=2.8e-07
X58 PAD_t3 VSSIO_t42 VSSIO_t44 VSSIO_t43 nfet_03v3 ad=41.6n pd=0.904m as=41.6n ps=0.904m w=4e-06 l=2.8e-07
X59 VSSIO_t83 VSSIO_t81 PAD_t7 VSSIO_t82 nfet_03v3 ad=41.6n pd=0.904m as=41.6n ps=0.904m w=4e-06 l=2.8e-07
X60 VSSIO_t193 GN_t20 a_n7856_9000_t21 VSSIO_t192 nfet_03v3 ad=20.8n pd=0.504m as=20.8n ps=0.504m w=2e-06 l=2.8e-07
X61 a_n7856_9000_t74 GP_t7 VDDIO_t89 VDDIO_t88 pfet_03v3 ad=52n pd=1.104m as=52n ps=1.104m w=5e-06 l=2.8e-07
X62 a_n1772_11080_t1 a_n3172_11920_t3 VDDIO_t13 VDDIO_t12 pfet_03v3 ad=35.2n pd=0.976m as=35.2n ps=0.976m w=2e-06 l=2.8e-07
X63 a_n7856_9000_t46 GP_t35 VDDIO_t31 VDDIO_t30 pfet_03v3 ad=52n pd=1.104m as=52n ps=1.104m w=5e-06 l=2.8e-07
X64 PAD_t22 VSSIO_t90 VSSIO_t92 VSSIO_t91 nfet_03v3 ad=41.6n pd=0.904m as=41.6n ps=0.904m w=4e-06 l=2.8e-07
X65 a_n7856_9000_t44 GP_t37 VDDIO_t27 VDDIO_t26 pfet_03v3 ad=52n pd=1.104m as=52n ps=1.104m w=5e-06 l=2.8e-07
X66 PAD_t10 VSSIO_t24 VSSIO_t26 VSSIO_t25 nfet_03v3 ad=41.6n pd=0.904m as=41.6n ps=0.904m w=4e-06 l=2.8e-07
X67 VDDIO_t87 GP_t6 a_n7856_9000_t75 VDDIO_t86 pfet_03v3 ad=52n pd=1.104m as=52n ps=1.104m w=5e-06 l=2.8e-07
X68 a_2028_11080_t1 a_628_11920_t3 VDDIO_t109 VDDIO_t108 pfet_03v3 ad=35.2n pd=0.976m as=35.2n ps=0.976m w=2e-06 l=2.8e-07
X69 a_n1772_11080_t0 a_n3172_11920_t4 VSSIO_t3 VSSIO_t2 nfet_03v3 ad=17.6n pd=0.576m as=17.6n ps=0.576m w=1e-06 l=2.8e-07
X70 a_n7856_9000_t28 GN_t13 VSSIO_t207 VSSIO_t206 nfet_03v3 ad=20.8n pd=0.504m as=20.8n ps=0.504m w=2e-06 l=2.8e-07
X71 VSSIO_t35 VSSIO_t33 PAD_t29 VSSIO_t34 nfet_03v3 ad=41.6n pd=0.904m as=41.6n ps=0.904m w=4e-06 l=2.8e-07
X72 VDDIO_t77 GP_t14 a_n7856_9000_t67 VDDIO_t76 pfet_03v3 ad=52n pd=1.104m as=52n ps=1.104m w=5e-06 l=2.8e-07
X73 VDDIO_t29 GP_t36 a_n7856_9000_t45 VDDIO_t28 pfet_03v3 ad=52n pd=1.104m as=52n ps=1.104m w=5e-06 l=2.8e-07
X74 a_2028_11080_t0 a_628_11920_t4 VSSIO_t139 VSSIO_t138 nfet_03v3 ad=17.6n pd=0.576m as=17.6n ps=0.576m w=1e-06 l=2.8e-07
X75 a_n7856_9000_t0 GN_t41 VSSIO_t149 VSSIO_t148 nfet_03v3 ad=20.8n pd=0.504m as=35.2n ps=0.976m w=2e-06 l=2.8e-07
X76 VSSIO_t199 GN_t14 a_n7856_9000_t27 VSSIO_t198 nfet_03v3 ad=20.8n pd=0.504m as=20.8n ps=0.504m w=2e-06 l=2.8e-07
X77 a_n7856_9000_t68 GP_t13 VDDIO_t75 VDDIO_t74 pfet_03v3 ad=52n pd=1.104m as=52n ps=1.104m w=5e-06 l=2.8e-07
X78 a_n4948_11920_t2 PU_OK_t0 VDDIO_t99 VDDIO_t98 pfet_03v3 ad=35.2n pd=0.976m as=35.2n ps=0.976m w=2e-06 l=2.8e-07
X79 VSSIO_t151 GN_t40 a_n7856_9000_t1 VSSIO_t150 nfet_03v3 ad=20.8n pd=0.504m as=20.8n ps=0.504m w=2e-06 l=2.8e-07
X80 a_n7856_9000_t40 GP_t41 VDDIO_t19 VDDIO_t18 pfet_03v3 ad=52n pd=1.104m as=88n ps=2.176m w=5e-06 l=2.8e-07
X81 VSSIO_t219 GN_t6 a_n7856_9000_t35 VSSIO_t218 nfet_03v3 ad=20.8n pd=0.504m as=20.8n ps=0.504m w=2e-06 l=2.8e-07
X82 VSSIO_t125 VSSIO_t123 PAD_t23 VSSIO_t124 nfet_03v3 ad=70.4n pd=1.776m as=41.6n ps=0.904m w=4e-06 l=2.8e-07
R_SERIES a_n7856_9000_t80 PAD_t40 22.272727
X84 a_n7856_9000_t6 GN_t35 VSSIO_t159 VSSIO_t158 nfet_03v3 ad=20.8n pd=0.504m as=20.8n ps=0.504m w=2e-06 l=2.8e-07
X85 a_n4948_11920_t0 a_n5372_11080_t2 VDDIO_t17 VDDIO_t16 pfet_03v3 ad=35.2n pd=0.976m as=35.2n ps=0.976m w=2e-06 l=2.8e-07
X86 a_n7856_9000_t34 GN_t7 VSSIO_t217 VSSIO_t216 nfet_03v3 ad=20.8n pd=0.504m as=20.8n ps=0.504m w=2e-06 l=2.8e-07
X87 VDDIO_t59 GP_t20 a_n7856_9000_t61 VDDIO_t58 pfet_03v3 ad=52n pd=1.104m as=52n ps=1.104m w=5e-06 l=2.8e-07
X88 VSSIO_t107 VSSIO_t105 PAD_t31 VSSIO_t106 nfet_03v3 ad=41.6n pd=0.904m as=41.6n ps=0.904m w=4e-06 l=2.8e-07
X89 VSSIO_t17 VSSIO_t15 PAD_t16 VSSIO_t16 nfet_03v3 ad=41.6n pd=0.904m as=41.6n ps=0.904m w=4e-06 l=2.8e-07
X90 GN_t0 a_2028_11080_t2 VDDIO_t15 VDDIO_t14 pfet_03v3 ad=35.2n pd=0.976m as=35.2n ps=0.976m w=2e-06 l=2.8e-07
X91 VSSIO_t171 GN_t30 a_n7856_9000_t11 VSSIO_t170 nfet_03v3 ad=20.8n pd=0.504m as=20.8n ps=0.504m w=2e-06 l=2.8e-07
X92 VSSIO_t175 GN_t28 a_n7856_9000_t13 VSSIO_t174 nfet_03v3 ad=20.8n pd=0.504m as=20.8n ps=0.504m w=2e-06 l=2.8e-07
X93 PAD_t30 VSSIO_t114 VSSIO_t116 VSSIO_t115 nfet_03v3 ad=41.6n pd=0.904m as=41.6n ps=0.904m w=4e-06 l=2.8e-07
X94 PAD_t17 VSSIO_t48 VSSIO_t50 VSSIO_t49 nfet_03v3 ad=41.6n pd=0.904m as=41.6n ps=0.904m w=4e-06 l=2.8e-07
X95 GN_t1 a_2028_11080_t3 VSSIO_t147 VSSIO_t146 nfet_03v3 ad=17.6n pd=0.576m as=17.6n ps=0.576m w=1e-06 l=2.8e-07
X96 a_n7856_9000_t54 GP_t27 VDDIO_t47 VDDIO_t46 pfet_03v3 ad=52n pd=1.104m as=52n ps=1.104m w=5e-06 l=2.8e-07
X97 a_n7856_9000_t12 GN_t29 VSSIO_t173 VSSIO_t172 nfet_03v3 ad=20.8n pd=0.504m as=20.8n ps=0.504m w=2e-06 l=2.8e-07
X98 VSSIO_t59 VSSIO_t57 PAD_t26 VSSIO_t58 nfet_03v3 ad=41.6n pd=0.904m as=41.6n ps=0.904m w=4e-06 l=2.8e-07
X99 PAD_t34 VSSIO_t96 VSSIO_t98 VSSIO_t97 nfet_03v3 ad=41.6n pd=0.904m as=41.6n ps=0.904m w=4e-06 l=2.8e-07
X100 a_n7856_9000_t18 GN_t23 VSSIO_t181 VSSIO_t180 nfet_03v3 ad=20.8n pd=0.504m as=20.8n ps=0.504m w=2e-06 l=2.8e-07
X101 PAD_t1 VSSIO_t30 VSSIO_t32 VSSIO_t31 nfet_03v3 ad=41.6n pd=0.904m as=41.6n ps=0.904m w=4e-06 l=2.8e-07
X102 a_n5372_11080_t1 OE_N_t0 VDDIO_t4 VDDIO_t3 pfet_03v3 ad=35.2n pd=0.976m as=35.2n ps=0.976m w=2e-06 l=2.8e-07
X103 VDDIO_t93 GP_t4 a_n7856_9000_t77 VDDIO_t92 pfet_03v3 ad=52n pd=1.104m as=52n ps=1.104m w=5e-06 l=2.8e-07
X104 VDDIO_t49 GP_t26 a_n7856_9000_t55 VDDIO_t48 pfet_03v3 ad=52n pd=1.104m as=52n ps=1.104m w=5e-06 l=2.8e-07
X105 a_628_11920_t1 OUT_t0 a_628_11080_t0 VDDIO_t11 pfet_03v3 ad=35.2n pd=0.976m as=35.2n ps=0.976m w=2e-06 l=2.8e-07
X106 a_n7856_9000_t20 GN_t21 VSSIO_t191 VSSIO_t190 nfet_03v3 ad=20.8n pd=0.504m as=20.8n ps=0.504m w=2e-06 l=2.8e-07
X107 VSSIO_t41 VSSIO_t39 PAD_t14 VSSIO_t40 nfet_03v3 ad=41.6n pd=0.904m as=41.6n ps=0.904m w=4e-06 l=2.8e-07
D2 VSSIO_t130 PAD_t43 diode_nd2ps_03v3 pj=3.2e-05 area=6.4e-11
X108 VSSIO_t187 GN_t24 a_n7856_9000_t17 VSSIO_t186 nfet_03v3 ad=20.8n pd=0.504m as=20.8n ps=0.504m w=2e-06 l=2.8e-07
X109 VDDIO_t33 GP_t34 a_n7856_9000_t47 VDDIO_t32 pfet_03v3 ad=52n pd=1.104m as=52n ps=1.104m w=5e-06 l=2.8e-07
X110 a_n5372_11080_t0 OE_N_t1 VSSIO_t127 VSSIO_t126 nfet_03v3 ad=17.6n pd=0.576m as=17.6n ps=0.576m w=1e-06 l=2.8e-07
X111 a_628_11920_t2 OUT_t2 VSSIO_t137 VSSIO_t136 nfet_03v3 ad=17.6n pd=0.576m as=17.6n ps=0.576m w=1e-06 l=2.8e-07
X112 a_n7856_9000_t78 GP_t3 VDDIO_t95 VDDIO_t94 pfet_03v3 ad=52n pd=1.104m as=52n ps=1.104m w=5e-06 l=2.8e-07
X113 VSSIO_t189 GN_t22 a_n7856_9000_t19 VSSIO_t188 nfet_03v3 ad=20.8n pd=0.504m as=20.8n ps=0.504m w=2e-06 l=2.8e-07
X114 a_n7856_9000_t76 GP_t5 VDDIO_t63 VDDIO_t62 pfet_03v3 ad=52n pd=1.104m as=52n ps=1.104m w=5e-06 l=2.8e-07
X115 PAD_t19 VSSIO_t120 VSSIO_t122 VSSIO_t121 nfet_03v3 ad=41.6n pd=0.904m as=41.6n ps=0.904m w=4e-06 l=2.8e-07
X116 a_n7856_9000_t48 GP_t33 VDDIO_t35 VDDIO_t34 pfet_03v3 ad=52n pd=1.104m as=52n ps=1.104m w=5e-06 l=2.8e-07
X117 a_n7856_9000_t24 GN_t17 VSSIO_t205 VSSIO_t204 nfet_03v3 ad=20.8n pd=0.504m as=20.8n ps=0.504m w=2e-06 l=2.8e-07
X118 VDDIO_t83 GP_t10 a_n7856_9000_t71 VDDIO_t82 pfet_03v3 ad=52n pd=1.104m as=52n ps=1.104m w=5e-06 l=2.8e-07
X119 VSSIO_t65 VSSIO_t63 PAD_t25 VSSIO_t64 nfet_03v3 ad=41.6n pd=0.904m as=41.6n ps=0.904m w=4e-06 l=2.8e-07
X120 a_n7856_9000_t26 GN_t15 VSSIO_t195 VSSIO_t194 nfet_03v3 ad=20.8n pd=0.504m as=20.8n ps=0.504m w=2e-06 l=2.8e-07
X121 VDDIO_t71 GP_t12 a_n7856_9000_t69 VDDIO_t70 pfet_03v3 ad=52n pd=1.104m as=52n ps=1.104m w=5e-06 l=2.8e-07
X122 VDDIO_t21 GP_t40 a_n7856_9000_t41 VDDIO_t20 pfet_03v3 ad=52n pd=1.104m as=52n ps=1.104m w=5e-06 l=2.8e-07
X123 PAD_t39 VSSIO_t72 VSSIO_t74 VSSIO_t73 nfet_03v3 ad=41.6n pd=0.904m as=41.6n ps=0.904m w=4e-06 l=2.8e-07
X124 IN_t0 PAD_t41 VDDIO_t8 VDDIO_t7 pfet_03v3 ad=70.4n pd=1.776m as=70.4n ps=1.776m w=4e-06 l=2.8e-07
X125 VSSIO_t23 VSSIO_t21 PAD_t28 VSSIO_t22 nfet_03v3 ad=41.6n pd=0.904m as=41.6n ps=0.904m w=4e-06 l=2.8e-07
X126 VSSIO_t113 VSSIO_t111 PAD_t20 VSSIO_t112 nfet_03v3 ad=41.6n pd=0.904m as=41.6n ps=0.904m w=4e-06 l=2.8e-07
X127 a_n7856_9000_t70 GP_t11 VDDIO_t81 VDDIO_t80 pfet_03v3 ad=52n pd=1.104m as=52n ps=1.104m w=5e-06 l=2.8e-07
X128 VSSIO_t47 VSSIO_t45 PAD_t13 VSSIO_t46 nfet_03v3 ad=41.6n pd=0.904m as=41.6n ps=0.904m w=4e-06 l=2.8e-07
X129 a_n6172_11080_t1 OUT_t1 VDDIO_t10 VDDIO_t9 pfet_03v3 ad=35.2n pd=0.976m as=35.2n ps=0.976m w=2e-06 l=2.8e-07
X130 VSSIO_t215 GN_t8 a_n7856_9000_t33 VSSIO_t214 nfet_03v3 ad=20.8n pd=0.504m as=20.8n ps=0.504m w=2e-06 l=2.8e-07
X131 a_n7856_9000_t62 GP_t19 VDDIO_t61 VDDIO_t60 pfet_03v3 ad=52n pd=1.104m as=52n ps=1.104m w=5e-06 l=2.8e-07
X132 VSSIO_t163 GN_t36 a_n7856_9000_t5 VSSIO_t162 nfet_03v3 ad=20.8n pd=0.504m as=20.8n ps=0.504m w=2e-06 l=2.8e-07
X133 PAD_t4 VSSIO_t54 VSSIO_t56 VSSIO_t55 nfet_03v3 ad=41.6n pd=0.904m as=41.6n ps=0.904m w=4e-06 l=2.8e-07
X134 a_n6172_11080_t0 OUT_t3 VSSIO_t135 VSSIO_t134 nfet_03v3 ad=17.6n pd=0.576m as=17.6n ps=0.576m w=1e-06 l=2.8e-07
D3 PAD_t45 VDDIO_t5 diode_pd2nw_03v3 pj=3.2e-05 area=6.4e-11
X135 GP_t1 a_n972_11080_t2 VDDIO_t107 VDDIO_t106 pfet_03v3 ad=35.2n pd=0.976m as=35.2n ps=0.976m w=2e-06 l=2.8e-07
X136 VDDIO_t73 GP_t16 a_n7856_9000_t65 VDDIO_t72 pfet_03v3 ad=52n pd=1.104m as=52n ps=1.104m w=5e-06 l=2.8e-07
X137 a_n7856_9000_t32 GN_t9 VSSIO_t213 VSSIO_t212 nfet_03v3 ad=20.8n pd=0.504m as=20.8n ps=0.504m w=2e-06 l=2.8e-07
X138 a_n7856_9000_t10 GN_t31 VSSIO_t169 VSSIO_t168 nfet_03v3 ad=20.8n pd=0.504m as=20.8n ps=0.504m w=2e-06 l=2.8e-07
X139 VDDIO_t67 GP_t18 a_n7856_9000_t63 VDDIO_t66 pfet_03v3 ad=52n pd=1.104m as=52n ps=1.104m w=5e-06 l=2.8e-07
X140 a_628_11080_t1 a_n4948_11920_t3 VDDIO_t105 VDDIO_t104 pfet_03v3 ad=35.2n pd=0.976m as=35.2n ps=0.976m w=2e-06 l=2.8e-07
X141 a_n7856_9000_t4 GN_t37 VSSIO_t161 VSSIO_t160 nfet_03v3 ad=20.8n pd=0.504m as=20.8n ps=0.504m w=2e-06 l=2.8e-07
X142 a_n3172_11080_t0 a_n4948_11920_t4 VDDIO_t1 VDDIO_t0 pfet_03v3 ad=35.2n pd=0.976m as=35.2n ps=0.976m w=2e-06 l=2.8e-07
X143 PAD_t0 VSSIO_t36 VSSIO_t38 VSSIO_t37 nfet_03v3 ad=41.6n pd=0.904m as=41.6n ps=0.904m w=4e-06 l=2.8e-07
X144 GP_t0 a_n972_11080_t3 VSSIO_t143 VSSIO_t142 nfet_03v3 ad=17.6n pd=0.576m as=17.6n ps=0.576m w=1e-06 l=2.8e-07
X145 PAD_t2 VSSIO_t6 VSSIO_t8 VSSIO_t7 nfet_03v3 ad=41.6n pd=0.904m as=70.4n ps=1.776m w=4e-06 l=2.8e-07
X146 a_628_11920_t0 a_n4948_11920_t5 VSSIO_t5 VSSIO_t4 nfet_03v3 ad=17.6n pd=0.576m as=17.6n ps=0.576m w=1e-06 l=2.8e-07
X147 VSSIO_t167 GN_t32 a_n7856_9000_t9 VSSIO_t166 nfet_03v3 ad=20.8n pd=0.504m as=20.8n ps=0.504m w=2e-06 l=2.8e-07
X148 a_n3172_11920_t0 a_n4948_11920_t6 VSSIO_t1 VSSIO_t0 nfet_03v3 ad=17.6n pd=0.576m as=17.6n ps=0.576m w=1e-06 l=2.8e-07
R0 IN IN_t1 9.17375
R1 IN IN_t0 8.13509
R2 GN_n0 GN_t2 44.2698
R3 GN_n40 GN_n39 38.8567
R4 GN_n40 GN_n38 38.2238
R5 GN_n0 GN_t3 32.5898
R6 GN_n1 GN_t4 32.5898
R7 GN_n2 GN_t5 32.5898
R8 GN_n3 GN_t6 32.5898
R9 GN_n4 GN_t7 32.5898
R10 GN_n5 GN_t8 32.5898
R11 GN_n6 GN_t9 32.5898
R12 GN_n7 GN_t10 32.5898
R13 GN_n8 GN_t11 32.5898
R14 GN_n9 GN_t12 32.5898
R15 GN_n10 GN_t13 32.5898
R16 GN_n11 GN_t14 32.5898
R17 GN_n12 GN_t15 32.5898
R18 GN_n13 GN_t16 32.5898
R19 GN_n14 GN_t17 32.5898
R20 GN_n15 GN_t18 32.5898
R21 GN_n16 GN_t19 32.5898
R22 GN_n17 GN_t20 32.5898
R23 GN_n18 GN_t21 32.5898
R24 GN_n19 GN_t22 32.5898
R25 GN_n20 GN_t23 32.5898
R26 GN_n21 GN_t24 32.5898
R27 GN_n22 GN_t25 32.5898
R28 GN_n23 GN_t26 32.5898
R29 GN_n24 GN_t27 32.5898
R30 GN_n25 GN_t28 32.5898
R31 GN_n26 GN_t29 32.5898
R32 GN_n27 GN_t30 32.5898
R33 GN_n28 GN_t31 32.5898
R34 GN_n29 GN_t32 32.5898
R35 GN_n30 GN_t33 32.5898
R36 GN_n31 GN_t34 32.5898
R37 GN_n32 GN_t35 32.5898
R38 GN_n33 GN_t36 32.5898
R39 GN_n34 GN_t37 32.5898
R40 GN_n35 GN_t38 32.5898
R41 GN_n36 GN_t39 32.5898
R42 GN_n37 GN_t40 32.5898
R43 GN_n38 GN_t41 32.5898
R44 GN_n38 GN_n37 11.6805
R45 GN_n37 GN_n36 11.6805
R46 GN_n36 GN_n35 11.6805
R47 GN_n35 GN_n34 11.6805
R48 GN_n34 GN_n33 11.6805
R49 GN_n33 GN_n32 11.6805
R50 GN_n32 GN_n31 11.6805
R51 GN_n31 GN_n30 11.6805
R52 GN_n30 GN_n29 11.6805
R53 GN_n29 GN_n28 11.6805
R54 GN_n28 GN_n27 11.6805
R55 GN_n27 GN_n26 11.6805
R56 GN_n26 GN_n25 11.6805
R57 GN_n25 GN_n24 11.6805
R58 GN_n24 GN_n23 11.6805
R59 GN_n23 GN_n22 11.6805
R60 GN_n22 GN_n21 11.6805
R61 GN_n21 GN_n20 11.6805
R62 GN_n20 GN_n19 11.6805
R63 GN_n19 GN_n18 11.6805
R64 GN_n18 GN_n17 11.6805
R65 GN_n17 GN_n16 11.6805
R66 GN_n16 GN_n15 11.6805
R67 GN_n15 GN_n14 11.6805
R68 GN_n14 GN_n13 11.6805
R69 GN_n13 GN_n12 11.6805
R70 GN_n12 GN_n11 11.6805
R71 GN_n11 GN_n10 11.6805
R72 GN_n10 GN_n9 11.6805
R73 GN_n9 GN_n8 11.6805
R74 GN_n8 GN_n7 11.6805
R75 GN_n7 GN_n6 11.6805
R76 GN_n6 GN_n5 11.6805
R77 GN_n5 GN_n4 11.6805
R78 GN_n4 GN_n3 11.6805
R79 GN_n3 GN_n2 11.6805
R80 GN_n2 GN_n1 11.6805
R81 GN_n1 GN_n0 11.6805
R82 GN_n39 GN_t1 5.15205
R83 GN_n39 GN_t0 2.69247
R84 GN GN_n40 0.0262143
R85 GP_n0 GP_t2 88.5912
R86 GP_n0 GP_t3 76.9112
R87 GP_n1 GP_t4 76.9112
R88 GP_n2 GP_t5 76.9112
R89 GP_n3 GP_t6 76.9112
R90 GP_n4 GP_t7 76.9112
R91 GP_n5 GP_t8 76.9112
R92 GP_n6 GP_t9 76.9112
R93 GP_n7 GP_t10 76.9112
R94 GP_n8 GP_t11 76.9112
R95 GP_n9 GP_t12 76.9112
R96 GP_n10 GP_t13 76.9112
R97 GP_n11 GP_t14 76.9112
R98 GP_n12 GP_t15 76.9112
R99 GP_n13 GP_t16 76.9112
R100 GP_n14 GP_t17 76.9112
R101 GP_n15 GP_t18 76.9112
R102 GP_n16 GP_t19 76.9112
R103 GP_n17 GP_t20 76.9112
R104 GP_n18 GP_t21 76.9112
R105 GP_n19 GP_t22 76.9112
R106 GP_n20 GP_t23 76.9112
R107 GP_n21 GP_t24 76.9112
R108 GP_n22 GP_t25 76.9112
R109 GP_n23 GP_t26 76.9112
R110 GP_n24 GP_t27 76.9112
R111 GP_n25 GP_t28 76.9112
R112 GP_n26 GP_t29 76.9112
R113 GP_n27 GP_t30 76.9112
R114 GP_n28 GP_t31 76.9112
R115 GP_n29 GP_t32 76.9112
R116 GP_n30 GP_t33 76.9112
R117 GP_n31 GP_t34 76.9112
R118 GP_n32 GP_t35 76.9112
R119 GP_n33 GP_t36 76.9112
R120 GP_n34 GP_t37 76.9112
R121 GP_n35 GP_t38 76.9112
R122 GP_n36 GP_t39 76.9112
R123 GP_n37 GP_t40 76.9112
R124 GP_n38 GP_t41 76.9112
R125 GP_n40 GP_n39 41.6287
R126 GP_n40 GP_n38 38.2238
R127 GP_n38 GP_n37 11.6805
R128 GP_n37 GP_n36 11.6805
R129 GP_n36 GP_n35 11.6805
R130 GP_n35 GP_n34 11.6805
R131 GP_n34 GP_n33 11.6805
R132 GP_n33 GP_n32 11.6805
R133 GP_n32 GP_n31 11.6805
R134 GP_n31 GP_n30 11.6805
R135 GP_n30 GP_n29 11.6805
R136 GP_n29 GP_n28 11.6805
R137 GP_n28 GP_n27 11.6805
R138 GP_n27 GP_n26 11.6805
R139 GP_n26 GP_n25 11.6805
R140 GP_n25 GP_n24 11.6805
R141 GP_n24 GP_n23 11.6805
R142 GP_n23 GP_n22 11.6805
R143 GP_n22 GP_n21 11.6805
R144 GP_n21 GP_n20 11.6805
R145 GP_n20 GP_n19 11.6805
R146 GP_n19 GP_n18 11.6805
R147 GP_n18 GP_n17 11.6805
R148 GP_n17 GP_n16 11.6805
R149 GP_n16 GP_n15 11.6805
R150 GP_n15 GP_n14 11.6805
R151 GP_n14 GP_n13 11.6805
R152 GP_n13 GP_n12 11.6805
R153 GP_n12 GP_n11 11.6805
R154 GP_n11 GP_n10 11.6805
R155 GP_n10 GP_n9 11.6805
R156 GP_n9 GP_n8 11.6805
R157 GP_n8 GP_n7 11.6805
R158 GP_n7 GP_n6 11.6805
R159 GP_n6 GP_n5 11.6805
R160 GP_n5 GP_n4 11.6805
R161 GP_n4 GP_n3 11.6805
R162 GP_n3 GP_n2 11.6805
R163 GP_n2 GP_n1 11.6805
R164 GP_n1 GP_n0 11.6805
R165 GP_n39 GP_t0 5.15205
R166 GP_n39 GP_t1 2.69247
R167 GP GP_n40 0.0262143
R168 PU_OK_t1 PU_OK_t0 119.407
R169 PU_OK PU_OK_t1 52.6952
R170 OE_N_t1 OE_N_t0 96.4648
R171 OE_N OE_N_t1 53.144
R172 OUT_t3 OUT_t1 96.4648
R173 OUT_t2 OUT_t0 96.4648
R174 OUT_n0 OUT_t2 47.237
R175 OUT_n0 OUT_t3 40.559
R176 OUT OUT_n0 12.8255
R177 PAD_n15 PAD_t41 108.495
R178 PAD_n15 PAD_t42 75.5435
R179 PAD_n16 PAD_n15 10.1705
R180 PAD_n111 PAD 7.7513
R181 PAD_n109 PAD_n108 7.13118
R182 PAD_n96 PAD_n95 6.47624
R183 PAD_n72 PAD_n71 6.47624
R184 PAD_n96 PAD_n94 6.11624
R185 PAD_n97 PAD_n93 6.11624
R186 PAD_n98 PAD_n92 6.11624
R187 PAD_n99 PAD_n91 6.11624
R188 PAD_n100 PAD_n90 6.11624
R189 PAD_n101 PAD_n89 6.11624
R190 PAD_n102 PAD_n88 6.11624
R191 PAD_n103 PAD_n87 6.11624
R192 PAD_n104 PAD_n86 6.11624
R193 PAD_n105 PAD_n85 6.11624
R194 PAD_n84 PAD_n64 6.11624
R195 PAD_n83 PAD_n65 6.11624
R196 PAD_n81 PAD_n66 6.11624
R197 PAD_n80 PAD_n67 6.11624
R198 PAD_n69 PAD_n68 6.11624
R199 PAD_n75 PAD_n74 6.11624
R200 PAD_n76 PAD_n73 6.11624
R201 PAD_n72 PAD_n70 6.11624
R202 PAD_n78 PAD_n77 4.9055
R203 PAD_n18 PAD_n16 4.5005
R204 PAD_n79 PAD_n78 4.5005
R205 PAD_n82 PAD_n63 4.5005
R206 PAD_n107 PAD_n106 4.5005
R207 PAD_n108 PAD_n107 3.41726
R208 PAD PAD_n205 1.3199
R209 PAD_n205 PAD 1.3199
R210 PAD_n205 PAD 1.3199
R211 PAD_n95 PAD_t2 0.41
R212 PAD_n95 PAD_t8 0.41
R213 PAD_n94 PAD_t6 0.41
R214 PAD_n94 PAD_t16 0.41
R215 PAD_n93 PAD_t9 0.41
R216 PAD_n93 PAD_t28 0.41
R217 PAD_n92 PAD_t10 0.41
R218 PAD_n92 PAD_t5 0.41
R219 PAD_n91 PAD_t1 0.41
R220 PAD_n91 PAD_t29 0.41
R221 PAD_n90 PAD_t0 0.41
R222 PAD_n90 PAD_t14 0.41
R223 PAD_n89 PAD_t3 0.41
R224 PAD_n89 PAD_t13 0.41
R225 PAD_n88 PAD_t17 0.41
R226 PAD_n88 PAD_t27 0.41
R227 PAD_n87 PAD_t4 0.41
R228 PAD_n87 PAD_t26 0.41
R229 PAD_n86 PAD_t12 0.41
R230 PAD_n86 PAD_t25 0.41
R231 PAD_n85 PAD_t15 0.41
R232 PAD_n85 PAD_t18 0.41
R233 PAD_n64 PAD_t39 0.41
R234 PAD_n64 PAD_t35 0.41
R235 PAD_n65 PAD_t11 0.41
R236 PAD_n65 PAD_t7 0.41
R237 PAD_n66 PAD_t38 0.41
R238 PAD_n66 PAD_t21 0.41
R239 PAD_n67 PAD_t22 0.41
R240 PAD_n67 PAD_t32 0.41
R241 PAD_n68 PAD_t34 0.41
R242 PAD_n68 PAD_t37 0.41
R243 PAD_n74 PAD_t24 0.41
R244 PAD_n74 PAD_t31 0.41
R245 PAD_n73 PAD_t36 0.41
R246 PAD_n73 PAD_t20 0.41
R247 PAD_n70 PAD_t30 0.41
R248 PAD_n70 PAD_t33 0.41
R249 PAD_n71 PAD_t19 0.41
R250 PAD_n71 PAD_t23 0.41
R251 PAD_n107 PAD_n63 0.4055
R252 PAD_n78 PAD_n63 0.4055
R253 PAD_n97 PAD_n96 0.3605
R254 PAD_n98 PAD_n97 0.3605
R255 PAD_n99 PAD_n98 0.3605
R256 PAD_n100 PAD_n99 0.3605
R257 PAD_n101 PAD_n100 0.3605
R258 PAD_n102 PAD_n101 0.3605
R259 PAD_n103 PAD_n102 0.3605
R260 PAD_n104 PAD_n103 0.3605
R261 PAD_n105 PAD_n104 0.3605
R262 PAD_n84 PAD_n83 0.3605
R263 PAD_n81 PAD_n80 0.3605
R264 PAD_n75 PAD_n69 0.3605
R265 PAD_n76 PAD_n75 0.3605
R266 PAD_n77 PAD_n72 0.32675
R267 PAD_n108 PAD 0.310515
R268 PAD_n80 PAD_n79 0.30425
R269 PAD PAD_t40 0.280213
R270 PAD_n106 PAD_n84 0.23675
R271 PAD_n83 PAD_n82 0.21425
R272 PAD_n82 PAD_n81 0.14675
R273 PAD_n202 PAD_n201 0.143024
R274 PAD_n116 PAD_n109 0.143024
R275 PAD_n110 PAD_n109 0.141125
R276 PAD_n203 PAD_n202 0.141125
R277 PAD_n2 PAD_n1 0.141125
R278 PAD_n198 PAD_n197 0.141125
R279 PAD_n7 PAD_n6 0.141125
R280 PAD_n193 PAD_n192 0.141125
R281 PAD_n10 PAD_n9 0.141125
R282 PAD_n186 PAD_n185 0.141125
R283 PAD_n17 PAD_n14 0.141125
R284 PAD_n181 PAD_n180 0.141125
R285 PAD_n21 PAD_n20 0.141125
R286 PAD_n174 PAD_n173 0.141125
R287 PAD_n26 PAD_n25 0.141125
R288 PAD_n169 PAD_n168 0.141125
R289 PAD_n29 PAD_n28 0.141125
R290 PAD_n162 PAD_n161 0.141125
R291 PAD_n34 PAD_n33 0.141125
R292 PAD_n157 PAD_n156 0.141125
R293 PAD_n37 PAD_n36 0.141125
R294 PAD_n150 PAD_n149 0.141125
R295 PAD_n42 PAD_n41 0.141125
R296 PAD_n145 PAD_n144 0.141125
R297 PAD_n45 PAD_n44 0.141125
R298 PAD_n138 PAD_n137 0.141125
R299 PAD_n50 PAD_n49 0.141125
R300 PAD_n133 PAD_n132 0.141125
R301 PAD_n53 PAD_n52 0.141125
R302 PAD_n126 PAD_n125 0.141125
R303 PAD_n58 PAD_n57 0.141125
R304 PAD_n121 PAD_n120 0.141125
R305 PAD_n61 PAD_n60 0.141125
R306 PAD_n114 PAD_n113 0.141125
R307 PAD_n113 PAD_n112 0.141125
R308 PAD_n60 PAD_n59 0.141125
R309 PAD_n122 PAD_n121 0.141125
R310 PAD_n123 PAD_n58 0.141125
R311 PAD_n125 PAD_n124 0.141125
R312 PAD_n52 PAD_n51 0.141125
R313 PAD_n134 PAD_n133 0.141125
R314 PAD_n135 PAD_n50 0.141125
R315 PAD_n137 PAD_n136 0.141125
R316 PAD_n44 PAD_n43 0.141125
R317 PAD_n146 PAD_n145 0.141125
R318 PAD_n147 PAD_n42 0.141125
R319 PAD_n149 PAD_n148 0.141125
R320 PAD_n36 PAD_n35 0.141125
R321 PAD_n158 PAD_n157 0.141125
R322 PAD_n159 PAD_n34 0.141125
R323 PAD_n161 PAD_n160 0.141125
R324 PAD_n28 PAD_n27 0.141125
R325 PAD_n170 PAD_n169 0.141125
R326 PAD_n171 PAD_n26 0.141125
R327 PAD_n173 PAD_n172 0.141125
R328 PAD_n20 PAD_n19 0.141125
R329 PAD_n182 PAD_n181 0.141125
R330 PAD_n183 PAD_n17 0.141125
R331 PAD_n185 PAD_n184 0.141125
R332 PAD_n9 PAD_n8 0.141125
R333 PAD_n194 PAD_n193 0.141125
R334 PAD_n195 PAD_n7 0.141125
R335 PAD_n197 PAD_n196 0.141125
R336 PAD_n1 PAD_n0 0.141125
R337 PAD_n204 PAD_n203 0.141125
R338 PAD_n3 PAD_n2 0.141125
R339 PAD_n199 PAD_n198 0.141125
R340 PAD_n6 PAD_n5 0.141125
R341 PAD_n192 PAD_n191 0.141125
R342 PAD_n11 PAD_n10 0.141125
R343 PAD_n187 PAD_n186 0.141125
R344 PAD_n14 PAD_n13 0.141125
R345 PAD_n180 PAD_n179 0.141125
R346 PAD_n22 PAD_n21 0.141125
R347 PAD_n175 PAD_n174 0.141125
R348 PAD_n25 PAD_n24 0.141125
R349 PAD_n168 PAD_n167 0.141125
R350 PAD_n30 PAD_n29 0.141125
R351 PAD_n163 PAD_n162 0.141125
R352 PAD_n33 PAD_n32 0.141125
R353 PAD_n156 PAD_n155 0.141125
R354 PAD_n38 PAD_n37 0.141125
R355 PAD_n151 PAD_n150 0.141125
R356 PAD_n41 PAD_n40 0.141125
R357 PAD_n144 PAD_n143 0.141125
R358 PAD_n46 PAD_n45 0.141125
R359 PAD_n139 PAD_n138 0.141125
R360 PAD_n49 PAD_n48 0.141125
R361 PAD_n132 PAD_n131 0.141125
R362 PAD_n54 PAD_n53 0.141125
R363 PAD_n127 PAD_n126 0.141125
R364 PAD_n57 PAD_n56 0.141125
R365 PAD_n120 PAD_n119 0.141125
R366 PAD_n62 PAD_n61 0.141125
R367 PAD_n115 PAD_n114 0.141125
R368 PAD_n200 PAD_n199 0.141125
R369 PAD_n5 PAD_n4 0.141125
R370 PAD_n191 PAD_n190 0.141125
R371 PAD_n189 PAD_n11 0.141125
R372 PAD_n188 PAD_n187 0.141125
R373 PAD_n13 PAD_n12 0.141125
R374 PAD_n179 PAD_n178 0.141125
R375 PAD_n177 PAD_n22 0.141125
R376 PAD_n176 PAD_n175 0.141125
R377 PAD_n24 PAD_n23 0.141125
R378 PAD_n167 PAD_n166 0.141125
R379 PAD_n165 PAD_n30 0.141125
R380 PAD_n164 PAD_n163 0.141125
R381 PAD_n32 PAD_n31 0.141125
R382 PAD_n155 PAD_n154 0.141125
R383 PAD_n153 PAD_n38 0.141125
R384 PAD_n152 PAD_n151 0.141125
R385 PAD_n40 PAD_n39 0.141125
R386 PAD_n143 PAD_n142 0.141125
R387 PAD_n141 PAD_n46 0.141125
R388 PAD_n140 PAD_n139 0.141125
R389 PAD_n48 PAD_n47 0.141125
R390 PAD_n131 PAD_n130 0.141125
R391 PAD_n129 PAD_n54 0.141125
R392 PAD_n128 PAD_n127 0.141125
R393 PAD_n56 PAD_n55 0.141125
R394 PAD_n119 PAD_n118 0.141125
R395 PAD_n117 PAD_n62 0.141125
R396 PAD_n112 PAD_n111 0.140157
R397 PAD_n106 PAD_n105 0.12425
R398 PAD_n201 PAD_n200 0.0721774
R399 PAD_n117 PAD_n116 0.0721774
R400 PAD_n79 PAD_n69 0.05675
R401 PAD_n77 PAD_n76 0.03425
R402 PAD PAD_t43 0.0251094
R403 PAD PAD_t44 0.0251094
R404 PAD PAD_t45 0.0208125
R405 PAD_n203 PAD_n1 0.0033125
R406 PAD_n197 PAD_n1 0.0033125
R407 PAD_n197 PAD_n7 0.0033125
R408 PAD_n193 PAD_n7 0.0033125
R409 PAD_n193 PAD_n9 0.0033125
R410 PAD_n185 PAD_n17 0.0033125
R411 PAD_n181 PAD_n17 0.0033125
R412 PAD_n181 PAD_n20 0.0033125
R413 PAD_n173 PAD_n20 0.0033125
R414 PAD_n173 PAD_n26 0.0033125
R415 PAD_n169 PAD_n26 0.0033125
R416 PAD_n169 PAD_n28 0.0033125
R417 PAD_n161 PAD_n28 0.0033125
R418 PAD_n161 PAD_n34 0.0033125
R419 PAD_n157 PAD_n34 0.0033125
R420 PAD_n157 PAD_n36 0.0033125
R421 PAD_n149 PAD_n36 0.0033125
R422 PAD_n149 PAD_n42 0.0033125
R423 PAD_n145 PAD_n42 0.0033125
R424 PAD_n145 PAD_n44 0.0033125
R425 PAD_n137 PAD_n44 0.0033125
R426 PAD_n137 PAD_n50 0.0033125
R427 PAD_n133 PAD_n50 0.0033125
R428 PAD_n133 PAD_n52 0.0033125
R429 PAD_n125 PAD_n52 0.0033125
R430 PAD_n125 PAD_n58 0.0033125
R431 PAD_n121 PAD_n58 0.0033125
R432 PAD_n121 PAD_n60 0.0033125
R433 PAD_n113 PAD_n60 0.0033125
R434 PAD_n113 PAD_n110 0.0033125
R435 PAD_n204 PAD_n0 0.0033125
R436 PAD_n196 PAD_n0 0.0033125
R437 PAD_n196 PAD_n195 0.0033125
R438 PAD_n195 PAD_n194 0.0033125
R439 PAD_n194 PAD_n8 0.0033125
R440 PAD_n184 PAD_n8 0.0033125
R441 PAD_n184 PAD_n183 0.0033125
R442 PAD_n183 PAD_n182 0.0033125
R443 PAD_n182 PAD_n19 0.0033125
R444 PAD_n172 PAD_n19 0.0033125
R445 PAD_n172 PAD_n171 0.0033125
R446 PAD_n171 PAD_n170 0.0033125
R447 PAD_n170 PAD_n27 0.0033125
R448 PAD_n160 PAD_n27 0.0033125
R449 PAD_n160 PAD_n159 0.0033125
R450 PAD_n159 PAD_n158 0.0033125
R451 PAD_n158 PAD_n35 0.0033125
R452 PAD_n148 PAD_n35 0.0033125
R453 PAD_n148 PAD_n147 0.0033125
R454 PAD_n147 PAD_n146 0.0033125
R455 PAD_n146 PAD_n43 0.0033125
R456 PAD_n136 PAD_n43 0.0033125
R457 PAD_n136 PAD_n135 0.0033125
R458 PAD_n135 PAD_n134 0.0033125
R459 PAD_n134 PAD_n51 0.0033125
R460 PAD_n124 PAD_n51 0.0033125
R461 PAD_n124 PAD_n123 0.0033125
R462 PAD_n123 PAD_n122 0.0033125
R463 PAD_n122 PAD_n59 0.0033125
R464 PAD_n112 PAD_n59 0.0033125
R465 PAD_n202 PAD_n2 0.0033125
R466 PAD_n198 PAD_n2 0.0033125
R467 PAD_n198 PAD_n6 0.0033125
R468 PAD_n192 PAD_n6 0.0033125
R469 PAD_n192 PAD_n10 0.0033125
R470 PAD_n186 PAD_n14 0.0033125
R471 PAD_n180 PAD_n14 0.0033125
R472 PAD_n180 PAD_n21 0.0033125
R473 PAD_n174 PAD_n21 0.0033125
R474 PAD_n174 PAD_n25 0.0033125
R475 PAD_n168 PAD_n25 0.0033125
R476 PAD_n168 PAD_n29 0.0033125
R477 PAD_n162 PAD_n29 0.0033125
R478 PAD_n162 PAD_n33 0.0033125
R479 PAD_n156 PAD_n33 0.0033125
R480 PAD_n156 PAD_n37 0.0033125
R481 PAD_n150 PAD_n37 0.0033125
R482 PAD_n150 PAD_n41 0.0033125
R483 PAD_n144 PAD_n41 0.0033125
R484 PAD_n144 PAD_n45 0.0033125
R485 PAD_n138 PAD_n45 0.0033125
R486 PAD_n138 PAD_n49 0.0033125
R487 PAD_n132 PAD_n49 0.0033125
R488 PAD_n132 PAD_n53 0.0033125
R489 PAD_n126 PAD_n53 0.0033125
R490 PAD_n126 PAD_n57 0.0033125
R491 PAD_n120 PAD_n57 0.0033125
R492 PAD_n120 PAD_n61 0.0033125
R493 PAD_n114 PAD_n61 0.0033125
R494 PAD_n114 PAD_n109 0.0033125
R495 PAD_n199 PAD_n3 0.0033125
R496 PAD_n199 PAD_n5 0.0033125
R497 PAD_n191 PAD_n5 0.0033125
R498 PAD_n191 PAD_n11 0.0033125
R499 PAD_n187 PAD_n11 0.0033125
R500 PAD_n187 PAD_n13 0.0033125
R501 PAD_n179 PAD_n13 0.0033125
R502 PAD_n179 PAD_n22 0.0033125
R503 PAD_n175 PAD_n22 0.0033125
R504 PAD_n175 PAD_n24 0.0033125
R505 PAD_n167 PAD_n24 0.0033125
R506 PAD_n167 PAD_n30 0.0033125
R507 PAD_n163 PAD_n30 0.0033125
R508 PAD_n163 PAD_n32 0.0033125
R509 PAD_n155 PAD_n32 0.0033125
R510 PAD_n155 PAD_n38 0.0033125
R511 PAD_n151 PAD_n38 0.0033125
R512 PAD_n151 PAD_n40 0.0033125
R513 PAD_n143 PAD_n40 0.0033125
R514 PAD_n143 PAD_n46 0.0033125
R515 PAD_n139 PAD_n46 0.0033125
R516 PAD_n139 PAD_n48 0.0033125
R517 PAD_n131 PAD_n48 0.0033125
R518 PAD_n131 PAD_n54 0.0033125
R519 PAD_n127 PAD_n54 0.0033125
R520 PAD_n127 PAD_n56 0.0033125
R521 PAD_n119 PAD_n56 0.0033125
R522 PAD_n119 PAD_n62 0.0033125
R523 PAD_n115 PAD_n62 0.0033125
R524 PAD_n18 PAD_n9 0.00256719
R525 PAD_n16 PAD_n10 0.00256719
R526 PAD_n201 PAD_n3 0.00238623
R527 PAD_n116 PAD_n115 0.00238623
R528 PAD_n200 PAD_n4 0.00175
R529 PAD_n190 PAD_n4 0.00175
R530 PAD_n190 PAD_n189 0.00175
R531 PAD_n189 PAD_n188 0.00175
R532 PAD_n188 PAD_n12 0.00175
R533 PAD_n178 PAD_n12 0.00175
R534 PAD_n178 PAD_n177 0.00175
R535 PAD_n177 PAD_n176 0.00175
R536 PAD_n176 PAD_n23 0.00175
R537 PAD_n166 PAD_n23 0.00175
R538 PAD_n166 PAD_n165 0.00175
R539 PAD_n165 PAD_n164 0.00175
R540 PAD_n164 PAD_n31 0.00175
R541 PAD_n154 PAD_n31 0.00175
R542 PAD_n154 PAD_n153 0.00175
R543 PAD_n153 PAD_n152 0.00175
R544 PAD_n152 PAD_n39 0.00175
R545 PAD_n142 PAD_n39 0.00175
R546 PAD_n142 PAD_n141 0.00175
R547 PAD_n141 PAD_n140 0.00175
R548 PAD_n140 PAD_n47 0.00175
R549 PAD_n130 PAD_n47 0.00175
R550 PAD_n130 PAD_n129 0.00175
R551 PAD_n129 PAD_n128 0.00175
R552 PAD_n128 PAD_n55 0.00175
R553 PAD_n118 PAD_n55 0.00175
R554 PAD_n118 PAD_n117 0.00175
R555 PAD_n185 PAD_n18 0.00124531
R556 PAD_n205 PAD_n204 0.00124531
R557 PAD_n186 PAD_n16 0.00124531
R558 PAD_n111 PAD_n110 0.00102002
R559 VDDIO VDDIO_t5 526.747
R560 VDDIO VDDIO_t102 521.779
R561 VDDIO_n42 VDDIO_t9 395.611
R562 VDDIO_n43 VDDIO_t3 395.503
R563 VDDIO_n45 VDDIO_t98 395.503
R564 VDDIO_n47 VDDIO_t16 395.503
R565 VDDIO_n41 VDDIO_t0 395.503
R566 VDDIO_n39 VDDIO_t2 395.503
R567 VDDIO_n38 VDDIO_t12 395.503
R568 VDDIO_n36 VDDIO_t100 395.503
R569 VDDIO_n34 VDDIO_t106 395.503
R570 VDDIO_n32 VDDIO_t104 395.503
R571 VDDIO_n30 VDDIO_t11 395.503
R572 VDDIO_n29 VDDIO_t108 395.503
R573 VDDIO_n27 VDDIO_t14 395.503
R574 VDDIO_n66 VDDIO_t7 232.214
R575 VDDIO_n0 VDDIO_t18 192.674
R576 VDDIO_t18 VDDIO_t20 136.519
R577 VDDIO_t20 VDDIO_t24 136.519
R578 VDDIO_t24 VDDIO_t22 136.519
R579 VDDIO_t22 VDDIO_t26 136.519
R580 VDDIO_t26 VDDIO_t28 136.519
R581 VDDIO_t28 VDDIO_t30 136.519
R582 VDDIO_t30 VDDIO_t32 136.519
R583 VDDIO_t32 VDDIO_t34 136.519
R584 VDDIO_t34 VDDIO_t38 136.519
R585 VDDIO_t38 VDDIO_t40 136.519
R586 VDDIO_t40 VDDIO_t36 136.519
R587 VDDIO_t36 VDDIO_t42 136.519
R588 VDDIO_t42 VDDIO_t44 136.519
R589 VDDIO_t44 VDDIO_t46 136.519
R590 VDDIO_t46 VDDIO_t48 136.519
R591 VDDIO_t48 VDDIO_t52 136.519
R592 VDDIO_t52 VDDIO_t50 136.519
R593 VDDIO_t50 VDDIO_t54 136.519
R594 VDDIO_t54 VDDIO_t56 136.519
R595 VDDIO_t56 VDDIO_t64 136.519
R596 VDDIO_t64 VDDIO_t58 136.519
R597 VDDIO_t58 VDDIO_t60 136.519
R598 VDDIO_t60 VDDIO_t66 136.519
R599 VDDIO_t66 VDDIO_t68 136.519
R600 VDDIO_t68 VDDIO_t72 136.519
R601 VDDIO_t72 VDDIO_t78 136.519
R602 VDDIO_t78 VDDIO_t76 136.519
R603 VDDIO_t76 VDDIO_t74 136.519
R604 VDDIO_t74 VDDIO_t70 136.519
R605 VDDIO_t70 VDDIO_t80 136.519
R606 VDDIO_t80 VDDIO_t82 136.519
R607 VDDIO_t82 VDDIO_t84 136.519
R608 VDDIO_t84 VDDIO_t90 136.519
R609 VDDIO_t90 VDDIO_t88 136.519
R610 VDDIO_t88 VDDIO_t86 136.519
R611 VDDIO_t86 VDDIO_t62 136.519
R612 VDDIO_t62 VDDIO_t92 136.519
R613 VDDIO_t92 VDDIO_t94 136.519
R614 VDDIO_t94 VDDIO_t96 136.519
R615 VDDIO_n50 VDDIO_n49 14.0765
R616 VDDIO_n64 VDDIO_n63 10.7074
R617 VDDIO_n65 VDDIO_n64 8.4605
R618 VDDIO_n20 VDDIO_t97 7.27651
R619 VDDIO_n20 VDDIO_n19 6.55251
R620 VDDIO_n21 VDDIO_n18 6.55251
R621 VDDIO_n22 VDDIO_n17 6.55251
R622 VDDIO_n23 VDDIO_n16 6.55251
R623 VDDIO_n24 VDDIO_n15 6.55251
R624 VDDIO_n25 VDDIO_n14 6.55251
R625 VDDIO_n26 VDDIO_n13 6.55251
R626 VDDIO_n51 VDDIO_n12 6.55251
R627 VDDIO_n52 VDDIO_n11 6.55251
R628 VDDIO_n53 VDDIO_n10 6.55251
R629 VDDIO_n54 VDDIO_n9 6.55251
R630 VDDIO_n55 VDDIO_n8 6.55251
R631 VDDIO_n56 VDDIO_n7 6.55251
R632 VDDIO_n57 VDDIO_n6 6.55251
R633 VDDIO_n58 VDDIO_n5 6.55251
R634 VDDIO_n59 VDDIO_n4 6.55251
R635 VDDIO_n60 VDDIO_n3 6.55251
R636 VDDIO_n61 VDDIO_n2 6.55251
R637 VDDIO_n62 VDDIO_n1 6.55251
R638 VDDIO_n63 VDDIO_n0 5.80076
R639 VDDIO VDDIO_n66 5.58476
R640 VDDIO_n64 VDDIO 4.9355
R641 VDDIO_n65 VDDIO 4.9355
R642 VDDIO_n27 VDDIO_t15 3.0835
R643 VDDIO_n42 VDDIO_t10 2.9755
R644 VDDIO_n44 VDDIO_t4 2.9755
R645 VDDIO_n46 VDDIO_t99 2.9755
R646 VDDIO_n48 VDDIO_t17 2.9755
R647 VDDIO_n40 VDDIO_t1 2.9755
R648 VDDIO_n37 VDDIO_t13 2.9755
R649 VDDIO_n35 VDDIO_t101 2.9755
R650 VDDIO_n33 VDDIO_t107 2.9755
R651 VDDIO_n31 VDDIO_t105 2.9755
R652 VDDIO_n28 VDDIO_t109 2.9755
R653 VDDIO_n66 VDDIO_t8 1.21208
R654 VDDIO_n0 VDDIO_t19 1.1095
R655 VDDIO VDDIO_n65 1.0805
R656 VDDIO_n39 VDDIO_n38 0.5855
R657 VDDIO_n30 VDDIO_n29 0.5855
R658 VDDIO_n43 VDDIO_n42 0.4925
R659 VDDIO_n45 VDDIO_n44 0.4925
R660 VDDIO_n37 VDDIO_n36 0.4925
R661 VDDIO_n35 VDDIO_n34 0.4925
R662 VDDIO_n33 VDDIO_n32 0.4925
R663 VDDIO_n28 VDDIO_n27 0.4925
R664 VDDIO_n49 VDDIO_n41 0.4325
R665 VDDIO_n19 VDDIO_t93 0.3645
R666 VDDIO_n19 VDDIO_t95 0.3645
R667 VDDIO_n18 VDDIO_t87 0.3645
R668 VDDIO_n18 VDDIO_t63 0.3645
R669 VDDIO_n17 VDDIO_t91 0.3645
R670 VDDIO_n17 VDDIO_t89 0.3645
R671 VDDIO_n16 VDDIO_t83 0.3645
R672 VDDIO_n16 VDDIO_t85 0.3645
R673 VDDIO_n15 VDDIO_t71 0.3645
R674 VDDIO_n15 VDDIO_t81 0.3645
R675 VDDIO_n14 VDDIO_t77 0.3645
R676 VDDIO_n14 VDDIO_t75 0.3645
R677 VDDIO_n13 VDDIO_t73 0.3645
R678 VDDIO_n13 VDDIO_t79 0.3645
R679 VDDIO_n12 VDDIO_t67 0.3645
R680 VDDIO_n12 VDDIO_t69 0.3645
R681 VDDIO_n11 VDDIO_t59 0.3645
R682 VDDIO_n11 VDDIO_t61 0.3645
R683 VDDIO_n10 VDDIO_t57 0.3645
R684 VDDIO_n10 VDDIO_t65 0.3645
R685 VDDIO_n9 VDDIO_t51 0.3645
R686 VDDIO_n9 VDDIO_t55 0.3645
R687 VDDIO_n8 VDDIO_t49 0.3645
R688 VDDIO_n8 VDDIO_t53 0.3645
R689 VDDIO_n7 VDDIO_t45 0.3645
R690 VDDIO_n7 VDDIO_t47 0.3645
R691 VDDIO_n6 VDDIO_t37 0.3645
R692 VDDIO_n6 VDDIO_t43 0.3645
R693 VDDIO_n5 VDDIO_t39 0.3645
R694 VDDIO_n5 VDDIO_t41 0.3645
R695 VDDIO_n4 VDDIO_t33 0.3645
R696 VDDIO_n4 VDDIO_t35 0.3645
R697 VDDIO_n3 VDDIO_t29 0.3645
R698 VDDIO_n3 VDDIO_t31 0.3645
R699 VDDIO_n2 VDDIO_t23 0.3645
R700 VDDIO_n2 VDDIO_t27 0.3645
R701 VDDIO_n1 VDDIO_t21 0.3645
R702 VDDIO_n1 VDDIO_t25 0.3645
R703 VDDIO_n62 VDDIO_n61 0.3605
R704 VDDIO_n61 VDDIO_n60 0.3605
R705 VDDIO_n60 VDDIO_n59 0.3605
R706 VDDIO_n59 VDDIO_n58 0.3605
R707 VDDIO_n58 VDDIO_n57 0.3605
R708 VDDIO_n57 VDDIO_n56 0.3605
R709 VDDIO_n56 VDDIO_n55 0.3605
R710 VDDIO_n55 VDDIO_n54 0.3605
R711 VDDIO_n54 VDDIO_n53 0.3605
R712 VDDIO_n53 VDDIO_n52 0.3605
R713 VDDIO_n52 VDDIO_n51 0.3605
R714 VDDIO_n26 VDDIO_n25 0.3605
R715 VDDIO_n25 VDDIO_n24 0.3605
R716 VDDIO_n24 VDDIO_n23 0.3605
R717 VDDIO_n23 VDDIO_n22 0.3605
R718 VDDIO_n22 VDDIO_n21 0.3605
R719 VDDIO_n21 VDDIO_n20 0.3605
R720 VDDIO_n47 VDDIO_n46 0.3575
R721 VDDIO_n40 VDDIO_n39 0.3575
R722 VDDIO_n31 VDDIO_n30 0.3575
R723 VDDIO VDDIO_n62 0.345535
R724 VDDIO_n50 VDDIO_n26 0.221
R725 VDDIO_n51 VDDIO_n50 0.14
R726 VDDIO_n44 VDDIO_n43 0.1085
R727 VDDIO_n46 VDDIO_n45 0.1085
R728 VDDIO_n48 VDDIO_n47 0.1085
R729 VDDIO_n41 VDDIO_n40 0.1085
R730 VDDIO_n38 VDDIO_n37 0.1085
R731 VDDIO_n36 VDDIO_n35 0.1085
R732 VDDIO_n34 VDDIO_n33 0.1085
R733 VDDIO_n32 VDDIO_n31 0.1085
R734 VDDIO_n29 VDDIO_n28 0.1085
R735 VDDIO_n49 VDDIO_n48 0.0455
R736 VDDIO_n63 VDDIO 0.00259302
R737 VSSIO_n194 VSSIO_n191 23902.5
R738 VSSIO_n49 VSSIO_n48 14754
R739 VSSIO_n183 VSSIO_n9 14754
R740 VSSIO_n185 VSSIO_n7 14754
R741 VSSIO_n191 VSSIO_t130 7139.79
R742 VSSIO_n161 VSSIO_n45 6500
R743 VSSIO_n182 VSSIO_n10 6500
R744 VSSIO_n184 VSSIO_n8 6500
R745 VSSIO_n187 VSSIO_n5 6075.16
R746 VSSIO_n180 VSSIO_n12 6075.16
R747 VSSIO_n164 VSSIO_n44 6075.16
R748 VSSIO_n51 VSSIO_n47 6075.16
R749 VSSIO_n186 VSSIO_n6 6075.16
R750 VSSIO_n181 VSSIO_n11 5957.57
R751 VSSIO_n188 VSSIO_n187 3320.47
R752 VSSIO_n187 VSSIO_n186 2863.44
R753 VSSIO_n182 VSSIO_n181 2747.36
R754 VSSIO_n186 VSSIO_n185 2541.3
R755 VSSIO_n185 VSSIO_n184 2505.51
R756 VSSIO_n184 VSSIO_n183 2505.51
R757 VSSIO_n183 VSSIO_n182 2505.51
R758 VSSIO_n188 VSSIO_n4 2246.95
R759 VSSIO_n194 VSSIO_n189 2026.43
R760 VSSIO_n189 VSSIO_n188 1929.11
R761 VSSIO_n193 VSSIO_n191 1816.21
R762 VSSIO_t130 VSSIO_n190 1721.23
R763 VSSIO_n181 VSSIO_n180 1323.82
R764 VSSIO_n194 VSSIO_t132 1089.29
R765 VSSIO_n180 VSSIO_n179 839.062
R766 VSSIO_n195 VSSIO_n194 822.636
R767 VSSIO_n196 VSSIO_n195 700.774
R768 VSSIO_n190 VSSIO_t128 439.973
R769 VSSIO_n179 VSSIO_t148 350
R770 VSSIO_t152 VSSIO_t150 250
R771 VSSIO_t156 VSSIO_t152 250
R772 VSSIO_t160 VSSIO_t156 250
R773 VSSIO_t162 VSSIO_t158 250
R774 VSSIO_t158 VSSIO_t154 250
R775 VSSIO_t154 VSSIO_t164 250
R776 VSSIO_t164 VSSIO_t166 250
R777 VSSIO_t168 VSSIO_t170 250
R778 VSSIO_t170 VSSIO_t172 250
R779 VSSIO_t172 VSSIO_t174 250
R780 VSSIO_t176 VSSIO_t182 250
R781 VSSIO_t182 VSSIO_t178 250
R782 VSSIO_t178 VSSIO_t186 250
R783 VSSIO_t186 VSSIO_t180 250
R784 VSSIO_t180 VSSIO_t188 250
R785 VSSIO_t188 VSSIO_t190 250
R786 VSSIO_t190 VSSIO_t192 250
R787 VSSIO_t192 VSSIO_t200 250
R788 VSSIO_t204 VSSIO_t196 250
R789 VSSIO_t202 VSSIO_t204 250
R790 VSSIO_t194 VSSIO_t202 250
R791 VSSIO_t198 VSSIO_t194 250
R792 VSSIO_t206 VSSIO_t198 250
R793 VSSIO_t184 VSSIO_t206 250
R794 VSSIO_t208 VSSIO_t184 250
R795 VSSIO_t210 VSSIO_t208 250
R796 VSSIO_t212 VSSIO_t210 250
R797 VSSIO_t214 VSSIO_t212 250
R798 VSSIO_t216 VSSIO_t214 250
R799 VSSIO_t218 VSSIO_t216 250
R800 VSSIO_t220 VSSIO_t218 250
R801 VSSIO_t224 VSSIO_t222 250
R802 VSSIO_t222 VSSIO_t226 250
R803 VSSIO_t174 VSSIO_n44 248.439
R804 VSSIO_n45 VSSIO_t168 235.939
R805 VSSIO_n195 VSSIO_t200 223.439
R806 VSSIO_n5 VSSIO_t134 202.626
R807 VSSIO_t126 VSSIO_n6 202.626
R808 VSSIO_t230 VSSIO_n12 202.626
R809 VSSIO_t2 VSSIO_n11 202.321
R810 VSSIO_n143 VSSIO_n8 201.484
R811 VSSIO_t140 VSSIO_n10 196.918
R812 VSSIO_n43 VSSIO_t220 195.312
R813 VSSIO_t150 VSSIO_n47 189.062
R814 VSSIO_n48 VSSIO_t160 170.312
R815 VSSIO_n145 VSSIO_n7 155.822
R816 VSSIO_t0 VSSIO_n9 151.256
R817 VSSIO_t134 VSSIO_n4 127.855
R818 VSSIO_n146 VSSIO_t126 127.855
R819 VSSIO_n145 VSSIO_t228 127.855
R820 VSSIO_n143 VSSIO_t144 127.855
R821 VSSIO_n141 VSSIO_t0 127.855
R822 VSSIO_n139 VSSIO_t140 127.855
R823 VSSIO_n137 VSSIO_t2 127.855
R824 VSSIO_n135 VSSIO_t230 127.855
R825 VSSIO_n133 VSSIO_t142 127.855
R826 VSSIO_n132 VSSIO_t7 127.855
R827 VSSIO_n146 VSSIO_n5 126.142
R828 VSSIO_n133 VSSIO_n12 126.142
R829 VSSIO_n135 VSSIO_n11 125.825
R830 VSSIO_t228 VSSIO_n6 121.576
R831 VSSIO_t132 VSSIO_n193 121.334
R832 VSSIO_n141 VSSIO_n8 120.434
R833 VSSIO_n137 VSSIO_n10 120.434
R834 VSSIO_n196 VSSIO_t229 101.365
R835 VSSIO_t13 VSSIO_t16 91.3247
R836 VSSIO_t31 VSSIO_t28 91.3247
R837 VSSIO_t34 VSSIO_t31 91.3247
R838 VSSIO_t46 VSSIO_t43 91.3247
R839 VSSIO_t52 VSSIO_t49 91.3247
R840 VSSIO_t58 VSSIO_t61 91.3247
R841 VSSIO_n164 VSSIO_t46 90.7539
R842 VSSIO_t4 VSSIO_t19 89.0416
R843 VSSIO_t37 VSSIO_n161 86.1877
R844 VSSIO_t61 VSSIO_t64 83.3007
R845 VSSIO_t64 VSSIO_t67 82.9881
R846 VSSIO_t67 VSSIO_t70 82.9881
R847 VSSIO_t70 VSSIO_t73 82.9881
R848 VSSIO_t73 VSSIO_t76 82.9881
R849 VSSIO_t76 VSSIO_t79 82.9881
R850 VSSIO_t79 VSSIO_t82 82.9881
R851 VSSIO_t82 VSSIO_t85 82.9881
R852 VSSIO_t85 VSSIO_t88 82.9881
R853 VSSIO_t88 VSSIO_t91 82.9881
R854 VSSIO_t91 VSSIO_t94 82.9881
R855 VSSIO_t94 VSSIO_t97 82.9881
R856 VSSIO_t97 VSSIO_t100 82.9881
R857 VSSIO_t100 VSSIO_t103 82.9881
R858 VSSIO_t103 VSSIO_t106 82.9881
R859 VSSIO_t106 VSSIO_t109 82.9881
R860 VSSIO_t109 VSSIO_t112 82.9881
R861 VSSIO_t112 VSSIO_t115 82.9881
R862 VSSIO_t118 VSSIO_t121 82.9881
R863 VSSIO_t121 VSSIO_t124 82.9881
R864 VSSIO_t136 VSSIO_t25 82.1923
R865 VSSIO_n48 VSSIO_t162 79.688
R866 VSSIO_n139 VSSIO_n9 74.7722
R867 VSSIO_t138 VSSIO_t40 70.7768
R868 VSSIO_t55 VSSIO_t146 70.7768
R869 VSSIO_n91 VSSIO_t123 70.3412
R870 VSSIO_t144 VSSIO_n7 70.206
R871 VSSIO_n51 VSSIO_t10 69.0644
R872 VSSIO_t115 VSSIO_n43 64.8345
R873 VSSIO_t19 VSSIO_n49 62.2151
R874 VSSIO_n47 VSSIO_t148 60.938
R875 VSSIO_n190 VSSIO_n189 59.7698
R876 VSSIO_n91 VSSIO_t120 58.6612
R877 VSSIO_n92 VSSIO_t117 58.6612
R878 VSSIO_n93 VSSIO_t114 58.6612
R879 VSSIO_n94 VSSIO_t111 58.6612
R880 VSSIO_n95 VSSIO_t108 58.6612
R881 VSSIO_n96 VSSIO_t105 58.6612
R882 VSSIO_n97 VSSIO_t102 58.6612
R883 VSSIO_n98 VSSIO_t99 58.6612
R884 VSSIO_n99 VSSIO_t96 58.6612
R885 VSSIO_n100 VSSIO_t93 58.6612
R886 VSSIO_n101 VSSIO_t90 58.6612
R887 VSSIO_n102 VSSIO_t87 58.6612
R888 VSSIO_n103 VSSIO_t84 58.6612
R889 VSSIO_n104 VSSIO_t81 58.6612
R890 VSSIO_n105 VSSIO_t78 58.6612
R891 VSSIO_n106 VSSIO_t75 58.6612
R892 VSSIO_n107 VSSIO_t72 58.6612
R893 VSSIO_n108 VSSIO_t69 58.6612
R894 VSSIO_n109 VSSIO_t66 58.6612
R895 VSSIO_n110 VSSIO_t63 58.6612
R896 VSSIO_n111 VSSIO_t60 58.6612
R897 VSSIO_n112 VSSIO_t57 58.6612
R898 VSSIO_n113 VSSIO_t54 58.6612
R899 VSSIO_n114 VSSIO_t51 58.6612
R900 VSSIO_n115 VSSIO_t48 58.6612
R901 VSSIO_n116 VSSIO_t45 58.6612
R902 VSSIO_n117 VSSIO_t42 58.6612
R903 VSSIO_n118 VSSIO_t39 58.6612
R904 VSSIO_n119 VSSIO_t36 58.6612
R905 VSSIO_n120 VSSIO_t33 58.6612
R906 VSSIO_n121 VSSIO_t30 58.6612
R907 VSSIO_n122 VSSIO_t27 58.6612
R908 VSSIO_n123 VSSIO_t24 58.6612
R909 VSSIO_n124 VSSIO_t21 58.6612
R910 VSSIO_n125 VSSIO_t18 58.6612
R911 VSSIO_n126 VSSIO_t15 58.6612
R912 VSSIO_n127 VSSIO_t12 58.6612
R913 VSSIO_n128 VSSIO_t9 58.6612
R914 VSSIO_n129 VSSIO_t6 58.6612
R915 VSSIO_t10 VSSIO_n50 57.0781
R916 VSSIO_t40 VSSIO_n163 57.0781
R917 VSSIO_n165 VSSIO_t55 57.0781
R918 VSSIO_n43 VSSIO_t224 54.688
R919 VSSIO_t142 VSSIO_n132 52.5119
R920 VSSIO_n160 VSSIO_t22 45.6626
R921 VSSIO_t25 VSSIO_n160 45.6626
R922 VSSIO_n130 VSSIO_n129 43.42
R923 VSSIO_n50 VSSIO_t13 34.2471
R924 VSSIO_n163 VSSIO_t37 34.2471
R925 VSSIO_n165 VSSIO_t52 34.2471
R926 VSSIO_n198 VSSIO_n197 33.233
R927 VSSIO_n49 VSSIO_t22 29.1101
R928 VSSIO_n195 VSSIO_t196 26.563
R929 VSSIO_t7 VSSIO_n51 22.2608
R930 VSSIO_t43 VSSIO_t138 20.5484
R931 VSSIO_t146 VSSIO_t58 20.5484
R932 VSSIO_n43 VSSIO_t118 18.154
R933 VSSIO_n168 VSSIO_n167 16.8827
R934 VSSIO_t166 VSSIO_n45 14.063
R935 VSSIO_n197 VSSIO_n3 13.595
R936 VSSIO_n198 VSSIO_n2 12.7831
R937 VSSIO_n197 VSSIO 12.4655
R938 VSSIO_n129 VSSIO_n128 11.6805
R939 VSSIO_n128 VSSIO_n127 11.6805
R940 VSSIO_n127 VSSIO_n126 11.6805
R941 VSSIO_n126 VSSIO_n125 11.6805
R942 VSSIO_n125 VSSIO_n124 11.6805
R943 VSSIO_n124 VSSIO_n123 11.6805
R944 VSSIO_n123 VSSIO_n122 11.6805
R945 VSSIO_n122 VSSIO_n121 11.6805
R946 VSSIO_n121 VSSIO_n120 11.6805
R947 VSSIO_n120 VSSIO_n119 11.6805
R948 VSSIO_n119 VSSIO_n118 11.6805
R949 VSSIO_n118 VSSIO_n117 11.6805
R950 VSSIO_n117 VSSIO_n116 11.6805
R951 VSSIO_n116 VSSIO_n115 11.6805
R952 VSSIO_n115 VSSIO_n114 11.6805
R953 VSSIO_n114 VSSIO_n113 11.6805
R954 VSSIO_n113 VSSIO_n112 11.6805
R955 VSSIO_n112 VSSIO_n111 11.6805
R956 VSSIO_n111 VSSIO_n110 11.6805
R957 VSSIO_n110 VSSIO_n109 11.6805
R958 VSSIO_n109 VSSIO_n108 11.6805
R959 VSSIO_n108 VSSIO_n107 11.6805
R960 VSSIO_n107 VSSIO_n106 11.6805
R961 VSSIO_n106 VSSIO_n105 11.6805
R962 VSSIO_n105 VSSIO_n104 11.6805
R963 VSSIO_n104 VSSIO_n103 11.6805
R964 VSSIO_n103 VSSIO_n102 11.6805
R965 VSSIO_n102 VSSIO_n101 11.6805
R966 VSSIO_n101 VSSIO_n100 11.6805
R967 VSSIO_n100 VSSIO_n99 11.6805
R968 VSSIO_n99 VSSIO_n98 11.6805
R969 VSSIO_n98 VSSIO_n97 11.6805
R970 VSSIO_n97 VSSIO_n96 11.6805
R971 VSSIO_n96 VSSIO_n95 11.6805
R972 VSSIO_n95 VSSIO_n94 11.6805
R973 VSSIO_n94 VSSIO_n93 11.6805
R974 VSSIO_n93 VSSIO_n92 11.6805
R975 VSSIO_n92 VSSIO_n91 11.6805
R976 VSSIO_n72 VSSIO 11.5725
R977 VSSIO_n1 VSSIO 9.2345
R978 VSSIO_t28 VSSIO_t136 9.13292
R979 VSSIO_n0 VSSIO 8.0555
R980 VSSIO_n3 VSSIO_t227 7.3895
R981 VSSIO_n71 VSSIO_t125 6.87816
R982 VSSIO_n32 VSSIO_n31 6.53225
R983 VSSIO_n33 VSSIO_n30 6.53225
R984 VSSIO_n34 VSSIO_n29 6.53225
R985 VSSIO_n35 VSSIO_n28 6.53225
R986 VSSIO_n36 VSSIO_n27 6.53225
R987 VSSIO_n37 VSSIO_n26 6.53225
R988 VSSIO_n38 VSSIO_n25 6.53225
R989 VSSIO_n39 VSSIO_n24 6.53225
R990 VSSIO_n40 VSSIO_n23 6.53225
R991 VSSIO_n41 VSSIO_n22 6.53225
R992 VSSIO_n169 VSSIO_n21 6.53225
R993 VSSIO_n170 VSSIO_n20 6.53225
R994 VSSIO_n171 VSSIO_n19 6.53225
R995 VSSIO_n172 VSSIO_n18 6.53225
R996 VSSIO_n173 VSSIO_n17 6.53225
R997 VSSIO_n174 VSSIO_n16 6.53225
R998 VSSIO_n175 VSSIO_n15 6.53225
R999 VSSIO_n176 VSSIO_n14 6.53225
R1000 VSSIO_n177 VSSIO_n13 6.53225
R1001 VSSIO_n71 VSSIO_n70 6.10866
R1002 VSSIO_n73 VSSIO_n69 6.10866
R1003 VSSIO_n74 VSSIO_n68 6.10866
R1004 VSSIO_n75 VSSIO_n67 6.10866
R1005 VSSIO_n76 VSSIO_n66 6.10866
R1006 VSSIO_n77 VSSIO_n65 6.10866
R1007 VSSIO_n78 VSSIO_n64 6.10866
R1008 VSSIO_n79 VSSIO_n63 6.10866
R1009 VSSIO_n80 VSSIO_n62 6.10866
R1010 VSSIO_n81 VSSIO_n61 6.10866
R1011 VSSIO_n82 VSSIO_n60 6.10866
R1012 VSSIO_n83 VSSIO_n59 6.10866
R1013 VSSIO_n84 VSSIO_n58 6.10866
R1014 VSSIO_n85 VSSIO_n57 6.10866
R1015 VSSIO_n86 VSSIO_n56 6.10866
R1016 VSSIO_n87 VSSIO_n55 6.10866
R1017 VSSIO_n88 VSSIO_n54 6.10866
R1018 VSSIO_n89 VSSIO_n53 6.10866
R1019 VSSIO_n90 VSSIO_n52 6.10866
R1020 VSSIO_n150 VSSIO_n145 5.66277
R1021 VSSIO_n0 VSSIO 5.5355
R1022 VSSIO_n131 VSSIO_n130 5.32116
R1023 VSSIO_n148 VSSIO_n4 5.2005
R1024 VSSIO_n147 VSSIO_n146 5.2005
R1025 VSSIO_n144 VSSIO_n143 5.2005
R1026 VSSIO_n142 VSSIO_n141 5.2005
R1027 VSSIO_n140 VSSIO_n139 5.2005
R1028 VSSIO_n138 VSSIO_n137 5.2005
R1029 VSSIO_n136 VSSIO_n135 5.2005
R1030 VSSIO_n134 VSSIO_n133 5.2005
R1031 VSSIO_n50 VSSIO_n46 5.2005
R1032 VSSIO_n160 VSSIO_n159 5.2005
R1033 VSSIO_n163 VSSIO_n162 5.2005
R1034 VSSIO_n166 VSSIO_n165 5.2005
R1035 VSSIO_n161 VSSIO_t34 5.13749
R1036 VSSIO_n192 VSSIO_n2 5.1222
R1037 VSSIO_n178 VSSIO 4.9595
R1038 VSSIO_n166 VSSIO_t147 4.901
R1039 VSSIO_n162 VSSIO_t139 4.901
R1040 VSSIO_n159 VSSIO_t137 4.901
R1041 VSSIO_n46 VSSIO_t5 4.901
R1042 VSSIO_n134 VSSIO_t143 4.901
R1043 VSSIO_n136 VSSIO_t231 4.901
R1044 VSSIO_n138 VSSIO_t3 4.901
R1045 VSSIO_n140 VSSIO_t141 4.901
R1046 VSSIO_n142 VSSIO_t1 4.901
R1047 VSSIO_n144 VSSIO_t145 4.901
R1048 VSSIO_n147 VSSIO_t127 4.901
R1049 VSSIO_n148 VSSIO_t135 4.901
R1050 VSSIO_n193 VSSIO_n192 2.93626
R1051 VSSIO_n179 VSSIO_n178 2.93626
R1052 VSSIO_n178 VSSIO_t149 2.3945
R1053 VSSIO_n192 VSSIO_t133 2.3945
R1054 VSSIO_n1 VSSIO_n0 2.3405
R1055 VSSIO_t16 VSSIO_t4 2.2836
R1056 VSSIO_n132 VSSIO_n131 1.59212
R1057 VSSIO_n44 VSSIO_t176 1.563
R1058 VSSIO VSSIO_n1 1.4405
R1059 VSSIO_n131 VSSIO_t8 1.1975
R1060 VSSIO_n149 VSSIO_n148 1.06277
R1061 VSSIO_n31 VSSIO_t225 0.8195
R1062 VSSIO_n31 VSSIO_t223 0.8195
R1063 VSSIO_n30 VSSIO_t219 0.8195
R1064 VSSIO_n30 VSSIO_t221 0.8195
R1065 VSSIO_n29 VSSIO_t215 0.8195
R1066 VSSIO_n29 VSSIO_t217 0.8195
R1067 VSSIO_n28 VSSIO_t211 0.8195
R1068 VSSIO_n28 VSSIO_t213 0.8195
R1069 VSSIO_n27 VSSIO_t185 0.8195
R1070 VSSIO_n27 VSSIO_t209 0.8195
R1071 VSSIO_n26 VSSIO_t199 0.8195
R1072 VSSIO_n26 VSSIO_t207 0.8195
R1073 VSSIO_n25 VSSIO_t203 0.8195
R1074 VSSIO_n25 VSSIO_t195 0.8195
R1075 VSSIO_n24 VSSIO_t197 0.8195
R1076 VSSIO_n24 VSSIO_t205 0.8195
R1077 VSSIO_n23 VSSIO_t193 0.8195
R1078 VSSIO_n23 VSSIO_t201 0.8195
R1079 VSSIO_n22 VSSIO_t189 0.8195
R1080 VSSIO_n22 VSSIO_t191 0.8195
R1081 VSSIO_n21 VSSIO_t187 0.8195
R1082 VSSIO_n21 VSSIO_t181 0.8195
R1083 VSSIO_n20 VSSIO_t183 0.8195
R1084 VSSIO_n20 VSSIO_t179 0.8195
R1085 VSSIO_n19 VSSIO_t175 0.8195
R1086 VSSIO_n19 VSSIO_t177 0.8195
R1087 VSSIO_n18 VSSIO_t171 0.8195
R1088 VSSIO_n18 VSSIO_t173 0.8195
R1089 VSSIO_n17 VSSIO_t167 0.8195
R1090 VSSIO_n17 VSSIO_t169 0.8195
R1091 VSSIO_n16 VSSIO_t155 0.8195
R1092 VSSIO_n16 VSSIO_t165 0.8195
R1093 VSSIO_n15 VSSIO_t163 0.8195
R1094 VSSIO_n15 VSSIO_t159 0.8195
R1095 VSSIO_n14 VSSIO_t157 0.8195
R1096 VSSIO_n14 VSSIO_t161 0.8195
R1097 VSSIO_n13 VSSIO_t151 0.8195
R1098 VSSIO_n13 VSSIO_t153 0.8195
R1099 VSSIO_n150 VSSIO_n149 0.7625
R1100 VSSIO_n155 VSSIO_n154 0.6005
R1101 VSSIO_n156 VSSIO_n155 0.6005
R1102 VSSIO_n157 VSSIO_n156 0.6005
R1103 VSSIO_n167 VSSIO_n42 0.6005
R1104 VSSIO_n154 VSSIO_n153 0.5855
R1105 VSSIO_n158 VSSIO_n42 0.5855
R1106 VSSIO_t49 VSSIO_n164 0.571276
R1107 VSSIO_n151 VSSIO_n150 0.4655
R1108 VSSIO_n153 VSSIO_n152 0.4655
R1109 VSSIO_n158 VSSIO_n157 0.4655
R1110 VSSIO_n167 VSSIO_n166 0.462773
R1111 VSSIO_n162 VSSIO_n42 0.462773
R1112 VSSIO_n159 VSSIO_n158 0.462773
R1113 VSSIO_n157 VSSIO_n46 0.462773
R1114 VSSIO_n156 VSSIO_n134 0.462773
R1115 VSSIO_n155 VSSIO_n136 0.462773
R1116 VSSIO_n154 VSSIO_n138 0.462773
R1117 VSSIO_n153 VSSIO_n140 0.462773
R1118 VSSIO_n152 VSSIO_n142 0.462773
R1119 VSSIO_n151 VSSIO_n144 0.462773
R1120 VSSIO_n149 VSSIO_n147 0.462773
R1121 VSSIO_n152 VSSIO_n151 0.4235
R1122 VSSIO_n70 VSSIO_t119 0.41
R1123 VSSIO_n70 VSSIO_t122 0.41
R1124 VSSIO_n69 VSSIO_t113 0.41
R1125 VSSIO_n69 VSSIO_t116 0.41
R1126 VSSIO_n68 VSSIO_t107 0.41
R1127 VSSIO_n68 VSSIO_t110 0.41
R1128 VSSIO_n67 VSSIO_t101 0.41
R1129 VSSIO_n67 VSSIO_t104 0.41
R1130 VSSIO_n66 VSSIO_t95 0.41
R1131 VSSIO_n66 VSSIO_t98 0.41
R1132 VSSIO_n65 VSSIO_t89 0.41
R1133 VSSIO_n65 VSSIO_t92 0.41
R1134 VSSIO_n64 VSSIO_t83 0.41
R1135 VSSIO_n64 VSSIO_t86 0.41
R1136 VSSIO_n63 VSSIO_t77 0.41
R1137 VSSIO_n63 VSSIO_t80 0.41
R1138 VSSIO_n62 VSSIO_t71 0.41
R1139 VSSIO_n62 VSSIO_t74 0.41
R1140 VSSIO_n61 VSSIO_t65 0.41
R1141 VSSIO_n61 VSSIO_t68 0.41
R1142 VSSIO_n60 VSSIO_t59 0.41
R1143 VSSIO_n60 VSSIO_t62 0.41
R1144 VSSIO_n59 VSSIO_t53 0.41
R1145 VSSIO_n59 VSSIO_t56 0.41
R1146 VSSIO_n58 VSSIO_t47 0.41
R1147 VSSIO_n58 VSSIO_t50 0.41
R1148 VSSIO_n57 VSSIO_t41 0.41
R1149 VSSIO_n57 VSSIO_t44 0.41
R1150 VSSIO_n56 VSSIO_t35 0.41
R1151 VSSIO_n56 VSSIO_t38 0.41
R1152 VSSIO_n55 VSSIO_t29 0.41
R1153 VSSIO_n55 VSSIO_t32 0.41
R1154 VSSIO_n54 VSSIO_t23 0.41
R1155 VSSIO_n54 VSSIO_t26 0.41
R1156 VSSIO_n53 VSSIO_t17 0.41
R1157 VSSIO_n53 VSSIO_t20 0.41
R1158 VSSIO_n52 VSSIO_t11 0.41
R1159 VSSIO_n52 VSSIO_t14 0.41
R1160 VSSIO_n177 VSSIO_n176 0.3605
R1161 VSSIO_n176 VSSIO_n175 0.3605
R1162 VSSIO_n175 VSSIO_n174 0.3605
R1163 VSSIO_n174 VSSIO_n173 0.3605
R1164 VSSIO_n173 VSSIO_n172 0.3605
R1165 VSSIO_n172 VSSIO_n171 0.3605
R1166 VSSIO_n171 VSSIO_n170 0.3605
R1167 VSSIO_n170 VSSIO_n169 0.3605
R1168 VSSIO_n41 VSSIO_n40 0.3605
R1169 VSSIO_n40 VSSIO_n39 0.3605
R1170 VSSIO_n39 VSSIO_n38 0.3605
R1171 VSSIO_n38 VSSIO_n37 0.3605
R1172 VSSIO_n37 VSSIO_n36 0.3605
R1173 VSSIO_n36 VSSIO_n35 0.3605
R1174 VSSIO_n35 VSSIO_n34 0.3605
R1175 VSSIO_n34 VSSIO_n33 0.3605
R1176 VSSIO_n33 VSSIO_n32 0.3605
R1177 VSSIO_n130 VSSIO_n90 0.3605
R1178 VSSIO_n90 VSSIO_n89 0.3605
R1179 VSSIO_n89 VSSIO_n88 0.3605
R1180 VSSIO_n88 VSSIO_n87 0.3605
R1181 VSSIO_n87 VSSIO_n86 0.3605
R1182 VSSIO_n86 VSSIO_n85 0.3605
R1183 VSSIO_n85 VSSIO_n84 0.3605
R1184 VSSIO_n84 VSSIO_n83 0.3605
R1185 VSSIO_n83 VSSIO_n82 0.3605
R1186 VSSIO_n82 VSSIO_n81 0.3605
R1187 VSSIO_n81 VSSIO_n80 0.3605
R1188 VSSIO_n80 VSSIO_n79 0.3605
R1189 VSSIO_n79 VSSIO_n78 0.3605
R1190 VSSIO_n78 VSSIO_n77 0.3605
R1191 VSSIO_n77 VSSIO_n76 0.3605
R1192 VSSIO_n76 VSSIO_n75 0.3605
R1193 VSSIO_n75 VSSIO_n74 0.3605
R1194 VSSIO_n74 VSSIO_n73 0.3605
R1195 VSSIO VSSIO_n177 0.35825
R1196 VSSIO_n32 VSSIO_n3 0.32225
R1197 VSSIO_n169 VSSIO_n168 0.32
R1198 VSSIO_n73 VSSIO_n72 0.25925
R1199 VSSIO VSSIO_n196 0.221777
R1200 VSSIO VSSIO_n198 0.1085
R1201 VSSIO_n72 VSSIO_n71 0.10175
R1202 VSSIO_n168 VSSIO_n41 0.041
R1203 VSSIO_n2 VSSIO 0.0272021
R1204 VSSIO VSSIO_t232 0.0122914
R1205 a_n7856_9000_n20 a_n7856_9000_t80 15.6427
R1206 a_n7856_9000_n39 a_n7856_9000_n0 6.66725
R1207 a_n7856_9000_n38 a_n7856_9000_n1 6.66725
R1208 a_n7856_9000_n37 a_n7856_9000_n2 6.66725
R1209 a_n7856_9000_n36 a_n7856_9000_n3 6.66725
R1210 a_n7856_9000_n35 a_n7856_9000_n4 6.66725
R1211 a_n7856_9000_n34 a_n7856_9000_n5 6.66725
R1212 a_n7856_9000_n33 a_n7856_9000_n6 6.66725
R1213 a_n7856_9000_n32 a_n7856_9000_n7 6.66725
R1214 a_n7856_9000_n31 a_n7856_9000_n8 6.66725
R1215 a_n7856_9000_n30 a_n7856_9000_n9 6.66725
R1216 a_n7856_9000_n29 a_n7856_9000_n10 6.66725
R1217 a_n7856_9000_n28 a_n7856_9000_n11 6.66725
R1218 a_n7856_9000_n27 a_n7856_9000_n12 6.66725
R1219 a_n7856_9000_n26 a_n7856_9000_n13 6.66725
R1220 a_n7856_9000_n25 a_n7856_9000_n14 6.66725
R1221 a_n7856_9000_n24 a_n7856_9000_n15 6.66725
R1222 a_n7856_9000_n23 a_n7856_9000_n16 6.66725
R1223 a_n7856_9000_n22 a_n7856_9000_n17 6.66725
R1224 a_n7856_9000_n21 a_n7856_9000_n18 6.66725
R1225 a_n7856_9000_n20 a_n7856_9000_n19 6.66725
R1226 a_n7856_9000_n59 a_n7856_9000_n58 6.34065
R1227 a_n7856_9000_n78 a_n7856_9000_n77 6.00576
R1228 a_n7856_9000_n59 a_n7856_9000_n57 6.00576
R1229 a_n7856_9000_n60 a_n7856_9000_n56 6.00576
R1230 a_n7856_9000_n61 a_n7856_9000_n55 6.00576
R1231 a_n7856_9000_n62 a_n7856_9000_n54 6.00576
R1232 a_n7856_9000_n63 a_n7856_9000_n53 6.00576
R1233 a_n7856_9000_n64 a_n7856_9000_n52 6.00576
R1234 a_n7856_9000_n65 a_n7856_9000_n51 6.00576
R1235 a_n7856_9000_n66 a_n7856_9000_n50 6.00576
R1236 a_n7856_9000_n67 a_n7856_9000_n49 6.00576
R1237 a_n7856_9000_n68 a_n7856_9000_n48 6.00576
R1238 a_n7856_9000_n69 a_n7856_9000_n47 6.00576
R1239 a_n7856_9000_n70 a_n7856_9000_n46 6.00576
R1240 a_n7856_9000_n71 a_n7856_9000_n45 6.00576
R1241 a_n7856_9000_n72 a_n7856_9000_n44 6.00576
R1242 a_n7856_9000_n73 a_n7856_9000_n43 6.00576
R1243 a_n7856_9000_n74 a_n7856_9000_n42 6.00576
R1244 a_n7856_9000_n75 a_n7856_9000_n41 6.00576
R1245 a_n7856_9000_n76 a_n7856_9000_n40 6.00576
R1246 a_n7856_9000_n77 a_n7856_9000_n39 2.08681
R1247 a_n7856_9000_n0 a_n7856_9000_t0 0.8195
R1248 a_n7856_9000_n0 a_n7856_9000_t1 0.8195
R1249 a_n7856_9000_n1 a_n7856_9000_t2 0.8195
R1250 a_n7856_9000_n1 a_n7856_9000_t3 0.8195
R1251 a_n7856_9000_n2 a_n7856_9000_t4 0.8195
R1252 a_n7856_9000_n2 a_n7856_9000_t5 0.8195
R1253 a_n7856_9000_n3 a_n7856_9000_t6 0.8195
R1254 a_n7856_9000_n3 a_n7856_9000_t7 0.8195
R1255 a_n7856_9000_n4 a_n7856_9000_t8 0.8195
R1256 a_n7856_9000_n4 a_n7856_9000_t9 0.8195
R1257 a_n7856_9000_n5 a_n7856_9000_t10 0.8195
R1258 a_n7856_9000_n5 a_n7856_9000_t11 0.8195
R1259 a_n7856_9000_n6 a_n7856_9000_t12 0.8195
R1260 a_n7856_9000_n6 a_n7856_9000_t13 0.8195
R1261 a_n7856_9000_n7 a_n7856_9000_t14 0.8195
R1262 a_n7856_9000_n7 a_n7856_9000_t15 0.8195
R1263 a_n7856_9000_n8 a_n7856_9000_t16 0.8195
R1264 a_n7856_9000_n8 a_n7856_9000_t17 0.8195
R1265 a_n7856_9000_n9 a_n7856_9000_t18 0.8195
R1266 a_n7856_9000_n9 a_n7856_9000_t19 0.8195
R1267 a_n7856_9000_n10 a_n7856_9000_t20 0.8195
R1268 a_n7856_9000_n10 a_n7856_9000_t21 0.8195
R1269 a_n7856_9000_n11 a_n7856_9000_t22 0.8195
R1270 a_n7856_9000_n11 a_n7856_9000_t23 0.8195
R1271 a_n7856_9000_n12 a_n7856_9000_t24 0.8195
R1272 a_n7856_9000_n12 a_n7856_9000_t25 0.8195
R1273 a_n7856_9000_n13 a_n7856_9000_t26 0.8195
R1274 a_n7856_9000_n13 a_n7856_9000_t27 0.8195
R1275 a_n7856_9000_n14 a_n7856_9000_t28 0.8195
R1276 a_n7856_9000_n14 a_n7856_9000_t29 0.8195
R1277 a_n7856_9000_n15 a_n7856_9000_t30 0.8195
R1278 a_n7856_9000_n15 a_n7856_9000_t31 0.8195
R1279 a_n7856_9000_n16 a_n7856_9000_t32 0.8195
R1280 a_n7856_9000_n16 a_n7856_9000_t33 0.8195
R1281 a_n7856_9000_n17 a_n7856_9000_t34 0.8195
R1282 a_n7856_9000_n17 a_n7856_9000_t35 0.8195
R1283 a_n7856_9000_n18 a_n7856_9000_t36 0.8195
R1284 a_n7856_9000_n18 a_n7856_9000_t37 0.8195
R1285 a_n7856_9000_n19 a_n7856_9000_t38 0.8195
R1286 a_n7856_9000_n19 a_n7856_9000_t39 0.8195
R1287 a_n7856_9000_n78 a_n7856_9000_t78 0.3645
R1288 a_n7856_9000_t79 a_n7856_9000_n78 0.3645
R1289 a_n7856_9000_n58 a_n7856_9000_t40 0.3645
R1290 a_n7856_9000_n58 a_n7856_9000_t41 0.3645
R1291 a_n7856_9000_n57 a_n7856_9000_t42 0.3645
R1292 a_n7856_9000_n57 a_n7856_9000_t43 0.3645
R1293 a_n7856_9000_n56 a_n7856_9000_t44 0.3645
R1294 a_n7856_9000_n56 a_n7856_9000_t45 0.3645
R1295 a_n7856_9000_n55 a_n7856_9000_t46 0.3645
R1296 a_n7856_9000_n55 a_n7856_9000_t47 0.3645
R1297 a_n7856_9000_n54 a_n7856_9000_t48 0.3645
R1298 a_n7856_9000_n54 a_n7856_9000_t49 0.3645
R1299 a_n7856_9000_n53 a_n7856_9000_t50 0.3645
R1300 a_n7856_9000_n53 a_n7856_9000_t51 0.3645
R1301 a_n7856_9000_n52 a_n7856_9000_t52 0.3645
R1302 a_n7856_9000_n52 a_n7856_9000_t53 0.3645
R1303 a_n7856_9000_n51 a_n7856_9000_t54 0.3645
R1304 a_n7856_9000_n51 a_n7856_9000_t55 0.3645
R1305 a_n7856_9000_n50 a_n7856_9000_t56 0.3645
R1306 a_n7856_9000_n50 a_n7856_9000_t57 0.3645
R1307 a_n7856_9000_n49 a_n7856_9000_t58 0.3645
R1308 a_n7856_9000_n49 a_n7856_9000_t59 0.3645
R1309 a_n7856_9000_n48 a_n7856_9000_t60 0.3645
R1310 a_n7856_9000_n48 a_n7856_9000_t61 0.3645
R1311 a_n7856_9000_n47 a_n7856_9000_t62 0.3645
R1312 a_n7856_9000_n47 a_n7856_9000_t63 0.3645
R1313 a_n7856_9000_n46 a_n7856_9000_t64 0.3645
R1314 a_n7856_9000_n46 a_n7856_9000_t65 0.3645
R1315 a_n7856_9000_n45 a_n7856_9000_t66 0.3645
R1316 a_n7856_9000_n45 a_n7856_9000_t67 0.3645
R1317 a_n7856_9000_n44 a_n7856_9000_t68 0.3645
R1318 a_n7856_9000_n44 a_n7856_9000_t69 0.3645
R1319 a_n7856_9000_n43 a_n7856_9000_t70 0.3645
R1320 a_n7856_9000_n43 a_n7856_9000_t71 0.3645
R1321 a_n7856_9000_n42 a_n7856_9000_t72 0.3645
R1322 a_n7856_9000_n42 a_n7856_9000_t73 0.3645
R1323 a_n7856_9000_n41 a_n7856_9000_t74 0.3645
R1324 a_n7856_9000_n41 a_n7856_9000_t75 0.3645
R1325 a_n7856_9000_n40 a_n7856_9000_t76 0.3645
R1326 a_n7856_9000_n40 a_n7856_9000_t77 0.3645
R1327 a_n7856_9000_n60 a_n7856_9000_n59 0.335384
R1328 a_n7856_9000_n61 a_n7856_9000_n60 0.335384
R1329 a_n7856_9000_n62 a_n7856_9000_n61 0.335384
R1330 a_n7856_9000_n63 a_n7856_9000_n62 0.335384
R1331 a_n7856_9000_n64 a_n7856_9000_n63 0.335384
R1332 a_n7856_9000_n65 a_n7856_9000_n64 0.335384
R1333 a_n7856_9000_n66 a_n7856_9000_n65 0.335384
R1334 a_n7856_9000_n67 a_n7856_9000_n66 0.335384
R1335 a_n7856_9000_n68 a_n7856_9000_n67 0.335384
R1336 a_n7856_9000_n69 a_n7856_9000_n68 0.335384
R1337 a_n7856_9000_n70 a_n7856_9000_n69 0.335384
R1338 a_n7856_9000_n71 a_n7856_9000_n70 0.335384
R1339 a_n7856_9000_n72 a_n7856_9000_n71 0.335384
R1340 a_n7856_9000_n73 a_n7856_9000_n72 0.335384
R1341 a_n7856_9000_n74 a_n7856_9000_n73 0.335384
R1342 a_n7856_9000_n75 a_n7856_9000_n74 0.335384
R1343 a_n7856_9000_n76 a_n7856_9000_n75 0.335384
R1344 a_n7856_9000_n77 a_n7856_9000_n76 0.335384
R1345 a_n7856_9000_n39 a_n7856_9000_n38 0.253132
R1346 a_n7856_9000_n38 a_n7856_9000_n37 0.253132
R1347 a_n7856_9000_n37 a_n7856_9000_n36 0.253132
R1348 a_n7856_9000_n36 a_n7856_9000_n35 0.253132
R1349 a_n7856_9000_n35 a_n7856_9000_n34 0.253132
R1350 a_n7856_9000_n34 a_n7856_9000_n33 0.253132
R1351 a_n7856_9000_n33 a_n7856_9000_n32 0.253132
R1352 a_n7856_9000_n32 a_n7856_9000_n31 0.253132
R1353 a_n7856_9000_n31 a_n7856_9000_n30 0.253132
R1354 a_n7856_9000_n30 a_n7856_9000_n29 0.253132
R1355 a_n7856_9000_n29 a_n7856_9000_n28 0.253132
R1356 a_n7856_9000_n28 a_n7856_9000_n27 0.253132
R1357 a_n7856_9000_n27 a_n7856_9000_n26 0.253132
R1358 a_n7856_9000_n26 a_n7856_9000_n25 0.253132
R1359 a_n7856_9000_n25 a_n7856_9000_n24 0.253132
R1360 a_n7856_9000_n24 a_n7856_9000_n23 0.253132
R1361 a_n7856_9000_n23 a_n7856_9000_n22 0.253132
R1362 a_n7856_9000_n22 a_n7856_9000_n21 0.253132
R1363 a_n7856_9000_n21 a_n7856_9000_n20 0.253132
R1364 a_628_11080_t0 a_628_11080_t1 6.08195
R1365 a_n3172_11080_t0 a_n3172_11080_t1 6.08195
R1366 a_n4804_11920_t0 a_n4804_11920_t1 10.5985
R1367 a_2028_11080_t3 a_2028_11080_t2 96.4648
R1368 a_2028_11080_n0 a_2028_11080_t3 56.8672
R1369 a_2028_11080_n0 a_2028_11080_t0 5.15205
R1370 a_2028_11080_t1 a_2028_11080_n0 2.69247
R1371 a_628_11920_t4 a_628_11920_t3 96.4648
R1372 a_628_11920_n0 a_628_11920_t4 51.971
R1373 a_628_11920_n0 a_628_11920_t0 9.50876
R1374 a_628_11920_n1 a_628_11920_n0 5.063
R1375 a_628_11920_n1 a_628_11920_t2 4.87376
R1376 a_628_11920_t1 a_628_11920_n1 2.97195
R1377 a_n972_11080_t3 a_n972_11080_t2 96.4648
R1378 a_n972_11080_n0 a_n972_11080_t3 55.4272
R1379 a_n972_11080_n0 a_n972_11080_t1 5.15205
R1380 a_n972_11080_t0 a_n972_11080_n0 2.69247
R1381 a_n1772_11080_t3 a_n1772_11080_t2 96.4648
R1382 a_n1772_11080_n0 a_n1772_11080_t3 54.9472
R1383 a_n1772_11080_n0 a_n1772_11080_t0 5.15205
R1384 a_n1772_11080_t1 a_n1772_11080_n0 2.69247
R1385 a_n3172_11920_t4 a_n3172_11920_t3 96.4648
R1386 a_n3172_11920_n0 a_n3172_11920_t4 50.051
R1387 a_n3172_11920_n0 a_n3172_11920_t0 9.50876
R1388 a_n3172_11920_n1 a_n3172_11920_n0 5.063
R1389 a_n3172_11920_n1 a_n3172_11920_t2 4.87376
R1390 a_n3172_11920_t1 a_n3172_11920_n1 2.97195
R1391 a_n6172_11080_t3 a_n6172_11080_t2 96.4648
R1392 a_n6172_11080_n0 a_n6172_11080_t3 55.5652
R1393 a_n6172_11080_n0 a_n6172_11080_t0 5.15205
R1394 a_n6172_11080_t1 a_n6172_11080_n0 2.69247
R1395 a_n4948_11920_t6 a_n4948_11920_t4 96.4648
R1396 a_n4948_11920_t5 a_n4948_11920_t3 96.4648
R1397 a_n4948_11920_n0 a_n4948_11920_t5 45.179
R1398 a_n4948_11920_n0 a_n4948_11920_t6 41.759
R1399 a_n4948_11920_n1 a_n4948_11920_t1 10.1312
R1400 a_n4948_11920_n2 a_n4948_11920_n0 7.8772
R1401 a_n4948_11920_n1 a_n4948_11920_t2 7.09797
R1402 a_n4948_11920_t0 a_n4948_11920_n2 7.09797
R1403 a_n4948_11920_n2 a_n4948_11920_n1 0.607022
R1404 a_n5372_11080_t3 a_n5372_11080_t2 119.407
R1405 a_n5372_11080_n0 a_n5372_11080_t3 53.8564
R1406 a_n5372_11080_n0 a_n5372_11080_t0 5.15205
R1407 a_n5372_11080_t1 a_n5372_11080_n0 2.69247
C0 GP VDDIO 7.34963f
C1 GN VSSIO 12.17808f
C2 GP VSSIO 8.30949f
C3 PU_OK VSSIO 4.38433f
C4 OE_N VSSIO 4.52714f
C5 OUT VSSIO 5.80163f
C6 PAD VSSIO 0.19764p
C7 VDDIO VSSIO 85.98227f
C8 VDDIO_t102 VSSIO 2.91501f
C9 OUT_n0 VSSIO 2.73011f
C10 GP_n39 VSSIO 2.06022f
.ends
