* Extracted by KLayout with GF180MCU LVS runset on : 18/11/2026 01:08

* cell gf180_pad_core
.SUBCKT gf180_pad_core
* device instance $1 r0 *1 -9.42,-60 pfet_03v3
M$1 IN PAD VDDIO VDDIO pfet_03v3 L=0.28U W=4U AS=1.76P AD=1.76P PS=8.88U
+ PD=8.88U
* device instance $2 r0 *1 -39.42,47.5 pfet_03v3
M$2 \$126 GP VDDIO VDDIO pfet_03v3 L=0.28U W=200U AS=52.9P AD=52.9P PS=226.16U
+ PD=226.16U
* device instance $42 r0 *1 -31,56.4 pfet_03v3
M$42 \$323 OUT VDDIO VDDIO pfet_03v3 L=0.28U W=2U AS=0.88P AD=0.88P PS=4.88U
+ PD=4.88U
* device instance $43 r0 *1 -27,56.4 pfet_03v3
M$43 \$324 OE_N VDDIO VDDIO pfet_03v3 L=0.28U W=2U AS=0.88P AD=0.88P PS=4.88U
+ PD=4.88U
* device instance $44 r0 *1 -23,56.4 pfet_03v3
M$44 \$325 PU_OK VDDIO VDDIO pfet_03v3 L=0.28U W=2U AS=0.88P AD=0.88P PS=4.88U
+ PD=4.88U
* device instance $45 r0 *1 -19.9,56.4 pfet_03v3
M$45 \$325 \$324 VDDIO VDDIO pfet_03v3 L=0.28U W=2U AS=0.88P AD=0.88P PS=4.88U
+ PD=4.88U
* device instance $46 r0 *1 -16,56.4 pfet_03v3
M$46 \$326 \$325 VDDIO VDDIO pfet_03v3 L=0.28U W=2U AS=0.88P AD=0.88P PS=4.88U
+ PD=4.88U
* device instance $47 r0 *1 -12.9,56.4 pfet_03v3
M$47 \$358 \$323 \$326 VDDIO pfet_03v3 L=0.28U W=2U AS=0.88P AD=0.88P PS=4.88U
+ PD=4.88U
* device instance $48 r0 *1 -9,56.4 pfet_03v3
M$48 \$327 \$358 VDDIO VDDIO pfet_03v3 L=0.28U W=2U AS=0.88P AD=0.88P PS=4.88U
+ PD=4.88U
* device instance $49 r0 *1 -5,56.4 pfet_03v3
M$49 \$328 \$327 VDDIO VDDIO pfet_03v3 L=0.28U W=2U AS=0.88P AD=0.88P PS=4.88U
+ PD=4.88U
* device instance $50 r0 *1 -1,56.4 pfet_03v3
M$50 GP \$328 VDDIO VDDIO pfet_03v3 L=0.28U W=2U AS=0.88P AD=0.88P PS=4.88U
+ PD=4.88U
* device instance $51 r0 *1 3,56.4 pfet_03v3
M$51 \$329 \$325 VDDIO VDDIO pfet_03v3 L=0.28U W=2U AS=0.88P AD=0.88P PS=4.88U
+ PD=4.88U
* device instance $52 r0 *1 6.1,56.4 pfet_03v3
M$52 \$359 OUT \$329 VDDIO pfet_03v3 L=0.28U W=2U AS=0.88P AD=0.88P PS=4.88U
+ PD=4.88U
* device instance $53 r0 *1 10,56.4 pfet_03v3
M$53 \$330 \$359 VDDIO VDDIO pfet_03v3 L=0.28U W=2U AS=0.88P AD=0.88P PS=4.88U
+ PD=4.88U
* device instance $54 r0 *1 14,56.4 pfet_03v3
M$54 GN \$330 VDDIO VDDIO pfet_03v3 L=0.28U W=2U AS=0.88P AD=0.88P PS=4.88U
+ PD=4.88U
* device instance $55 r0 *1 -9.42,-49 nfet_03v3
M$55 IN PAD VSSIO VSSIO nfet_03v3 L=0.28U W=2U AS=0.88P AD=0.88P PS=4.88U
+ PD=4.88U
* device instance $56 r0 *1 -60.32,-48.55 nfet_03v3
M$56 PAD VSSIO VSSIO VSSIO nfet_03v3 L=0.28U W=80U AS=21.52P AD=21.52P
+ PS=105.52U PD=105.52U
* device instance $96 r0 *1 -31,60.1 nfet_03v3
M$96 \$323 OUT VSSIO VSSIO nfet_03v3 L=0.28U W=1U AS=0.44P AD=0.44P PS=2.88U
+ PD=2.88U
* device instance $97 r0 *1 -27,60.1 nfet_03v3
M$97 \$324 OE_N VSSIO VSSIO nfet_03v3 L=0.28U W=1U AS=0.44P AD=0.44P PS=2.88U
+ PD=2.88U
* device instance $98 r0 *1 -24.16,60.1 nfet_03v3
M$98 \$357 PU_OK \$325 VSSIO nfet_03v3 L=0.28U W=1U AS=0.44P AD=0.44P PS=2.88U
+ PD=2.88U
* device instance $99 r0 *1 -21.06,60.1 nfet_03v3
M$99 VSSIO \$324 \$357 VSSIO nfet_03v3 L=0.28U W=1U AS=0.44P AD=0.44P PS=2.88U
+ PD=2.88U
* device instance $100 r0 *1 -16,60.1 nfet_03v3
M$100 \$358 \$325 VSSIO VSSIO nfet_03v3 L=0.28U W=1U AS=0.44P AD=0.44P PS=2.88U
+ PD=2.88U
* device instance $101 r0 *1 -12.9,60.1 nfet_03v3
M$101 \$358 \$323 VSSIO VSSIO nfet_03v3 L=0.28U W=1U AS=0.44P AD=0.44P PS=2.88U
+ PD=2.88U
* device instance $102 r0 *1 -9,60.1 nfet_03v3
M$102 \$327 \$358 VSSIO VSSIO nfet_03v3 L=0.28U W=1U AS=0.44P AD=0.44P PS=2.88U
+ PD=2.88U
* device instance $103 r0 *1 -5,60.1 nfet_03v3
M$103 \$328 \$327 VSSIO VSSIO nfet_03v3 L=0.28U W=1U AS=0.44P AD=0.44P PS=2.88U
+ PD=2.88U
* device instance $104 r0 *1 -1,60.1 nfet_03v3
M$104 GP \$328 VSSIO VSSIO nfet_03v3 L=0.28U W=1U AS=0.44P AD=0.44P PS=2.88U
+ PD=2.88U
* device instance $105 r0 *1 0.58,46 nfet_03v3
M$105 \$126 GN VSSIO VSSIO nfet_03v3 L=0.28U W=80U AS=21.16P AD=21.16P
+ PS=103.16U PD=103.16U
* device instance $145 r0 *1 3,60.1 nfet_03v3
M$145 \$359 \$325 VSSIO VSSIO nfet_03v3 L=0.28U W=1U AS=0.44P AD=0.44P PS=2.88U
+ PD=2.88U
* device instance $146 r0 *1 6.1,60.1 nfet_03v3
M$146 \$359 OUT VSSIO VSSIO nfet_03v3 L=0.28U W=1U AS=0.44P AD=0.44P PS=2.88U
+ PD=2.88U
* device instance $147 r0 *1 10,60.1 nfet_03v3
M$147 \$330 \$359 VSSIO VSSIO nfet_03v3 L=0.28U W=1U AS=0.44P AD=0.44P PS=2.88U
+ PD=2.88U
* device instance $148 r0 *1 14,60.1 nfet_03v3
M$148 GN \$330 VSSIO VSSIO nfet_03v3 L=0.28U W=1U AS=0.44P AD=0.44P PS=2.88U
+ PD=2.88U
* device instance $149 r0 *1 -50.16,-6 diode_nd2ps_03v3
D$149 VSSIO PAD diode_nd2ps_03v3 A=128P P=64U
* device instance $151 r0 *1 -49.16,-33 diode_pd2nw_03v3
D$151 VSSIO VDDIO diode_pd2nw_03v3 A=100P P=40U
* device instance $152 r0 *1 -50.16,14 diode_pd2nw_03v3
D$152 PAD VDDIO diode_pd2nw_03v3 A=64P P=32U
* device instance $153 r0 *1 36.7,0 ppolyf_u
R$153 \$126 PAD VSSIO 22.2727272727 ppolyf_u L=1.4U W=22U
.ENDS gf180_pad_core
