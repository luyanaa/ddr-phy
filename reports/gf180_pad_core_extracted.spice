* Extracted by KLayout with GF180MCU LVS runset on : 17/11/2026 21:30

* cell gf180_pad_core
.SUBCKT gf180_pad_core
* device instance $1 r0 *1 -9.42,-60 pfet_03v3
M$1 IN PAD VDDIO VDDIO pfet_03v3 L=0.28U W=4U AS=1.76P AD=1.76P PS=8.88U
+ PD=8.88U
* device instance $2 r0 *1 -39.42,47.5 pfet_03v3
M$2 \$84 GP VDDIO VDDIO pfet_03v3 L=0.28U W=200U AS=52.9P AD=52.9P PS=226.16U
+ PD=226.16U
* device instance $42 r0 *1 -31,56.4 pfet_03v3
M$42 \$343 OUT VDDIO VDDIO pfet_03v3 L=0.28U W=2U AS=0.88P AD=0.88P PS=4.88U
+ PD=4.88U
* device instance $43 r0 *1 -27,56.4 pfet_03v3
M$43 \$344 OE_N VDDIO VDDIO pfet_03v3 L=0.28U W=2U AS=0.88P AD=0.88P PS=4.88U
+ PD=4.88U
* device instance $44 r0 *1 -23,56.4 pfet_03v3
M$44 \$345 PU_OK VDDIO VDDIO pfet_03v3 L=0.28U W=2U AS=0.88P AD=0.88P PS=4.88U
+ PD=4.88U
* device instance $45 r0 *1 -19.9,56.4 pfet_03v3
M$45 \$345 \$344 VDDIO VDDIO pfet_03v3 L=0.28U W=2U AS=0.88P AD=0.88P PS=4.88U
+ PD=4.88U
* device instance $46 r0 *1 -16,56.4 pfet_03v3
M$46 \$346 \$345 VDDIO VDDIO pfet_03v3 L=0.28U W=2U AS=0.88P AD=0.88P PS=4.88U
+ PD=4.88U
* device instance $47 r0 *1 -12.9,56.4 pfet_03v3
M$47 \$375 \$343 \$346 VDDIO pfet_03v3 L=0.28U W=2U AS=0.88P AD=0.88P PS=4.88U
+ PD=4.88U
* device instance $48 r0 *1 -9,56.4 pfet_03v3
M$48 \$347 \$375 VDDIO VDDIO pfet_03v3 L=0.28U W=2U AS=0.88P AD=0.88P PS=4.88U
+ PD=4.88U
* device instance $49 r0 *1 -5,56.4 pfet_03v3
M$49 \$348 \$347 VDDIO VDDIO pfet_03v3 L=0.28U W=2U AS=0.88P AD=0.88P PS=4.88U
+ PD=4.88U
* device instance $50 r0 *1 -1,56.4 pfet_03v3
M$50 GP \$348 VDDIO VDDIO pfet_03v3 L=0.28U W=2U AS=0.88P AD=0.88P PS=4.88U
+ PD=4.88U
* device instance $51 r0 *1 3,56.4 pfet_03v3
M$51 \$349 \$345 VDDIO VDDIO pfet_03v3 L=0.28U W=2U AS=0.88P AD=0.88P PS=4.88U
+ PD=4.88U
* device instance $52 r0 *1 6.1,56.4 pfet_03v3
M$52 \$376 OUT \$349 VDDIO pfet_03v3 L=0.28U W=2U AS=0.88P AD=0.88P PS=4.88U
+ PD=4.88U
* device instance $53 r0 *1 10,56.4 pfet_03v3
M$53 \$350 \$376 VDDIO VDDIO pfet_03v3 L=0.28U W=2U AS=0.88P AD=0.88P PS=4.88U
+ PD=4.88U
* device instance $54 r0 *1 14,56.4 pfet_03v3
M$54 GN \$350 VDDIO VDDIO pfet_03v3 L=0.28U W=2U AS=0.88P AD=0.88P PS=4.88U
+ PD=4.88U
* device instance $55 r0 *1 -9.42,-49 nfet_03v3
M$55 IN PAD VSSIO VSSIO nfet_03v3 L=0.28U W=2U AS=0.88P AD=0.88P PS=4.88U
+ PD=4.88U
* device instance $56 r0 *1 0.58,46 nfet_03v3
M$56 \$84 GN VSSIO VSSIO nfet_03v3 L=0.28U W=80U AS=21.16P AD=21.16P PS=103.16U
+ PD=103.16U
* device instance $96 r0 *1 -31,60.1 nfet_03v3
M$96 \$343 OUT VSSIO VSSIO nfet_03v3 L=0.28U W=1U AS=0.44P AD=0.44P PS=2.88U
+ PD=2.88U
* device instance $97 r0 *1 -27,60.1 nfet_03v3
M$97 \$344 OE_N VSSIO VSSIO nfet_03v3 L=0.28U W=1U AS=0.44P AD=0.44P PS=2.88U
+ PD=2.88U
* device instance $98 r0 *1 -24.16,60.1 nfet_03v3
M$98 \$374 PU_OK \$345 VSSIO nfet_03v3 L=0.28U W=1U AS=0.44P AD=0.44P PS=2.88U
+ PD=2.88U
* device instance $99 r0 *1 -21.06,60.1 nfet_03v3
M$99 VSSIO \$344 \$374 VSSIO nfet_03v3 L=0.28U W=1U AS=0.44P AD=0.44P PS=2.88U
+ PD=2.88U
* device instance $100 r0 *1 -16,60.1 nfet_03v3
M$100 \$375 \$345 VSSIO VSSIO nfet_03v3 L=0.28U W=1U AS=0.44P AD=0.44P PS=2.88U
+ PD=2.88U
* device instance $101 r0 *1 -12.9,60.1 nfet_03v3
M$101 \$375 \$343 VSSIO VSSIO nfet_03v3 L=0.28U W=1U AS=0.44P AD=0.44P PS=2.88U
+ PD=2.88U
* device instance $102 r0 *1 -9,60.1 nfet_03v3
M$102 \$347 \$375 VSSIO VSSIO nfet_03v3 L=0.28U W=1U AS=0.44P AD=0.44P PS=2.88U
+ PD=2.88U
* device instance $103 r0 *1 -5,60.1 nfet_03v3
M$103 \$348 \$347 VSSIO VSSIO nfet_03v3 L=0.28U W=1U AS=0.44P AD=0.44P PS=2.88U
+ PD=2.88U
* device instance $104 r0 *1 -1,60.1 nfet_03v3
M$104 GP \$348 VSSIO VSSIO nfet_03v3 L=0.28U W=1U AS=0.44P AD=0.44P PS=2.88U
+ PD=2.88U
* device instance $105 r0 *1 3,60.1 nfet_03v3
M$105 \$376 \$345 VSSIO VSSIO nfet_03v3 L=0.28U W=1U AS=0.44P AD=0.44P PS=2.88U
+ PD=2.88U
* device instance $106 r0 *1 6.1,60.1 nfet_03v3
M$106 \$376 OUT VSSIO VSSIO nfet_03v3 L=0.28U W=1U AS=0.44P AD=0.44P PS=2.88U
+ PD=2.88U
* device instance $107 r0 *1 10,60.1 nfet_03v3
M$107 \$350 \$376 VSSIO VSSIO nfet_03v3 L=0.28U W=1U AS=0.44P AD=0.44P PS=2.88U
+ PD=2.88U
* device instance $108 r0 *1 14,60.1 nfet_03v3
M$108 GN \$350 VSSIO VSSIO nfet_03v3 L=0.28U W=1U AS=0.44P AD=0.44P PS=2.88U
+ PD=2.88U
* device instance $109 r0 *1 -52.16,-7.5 diode_nd2ps_03v3
D$109 VSSIO PAD diode_nd2ps_03v3 A=20P P=18U
* device instance $110 r0 *1 -49.16,-25 diode_pd2nw_03v3
D$110 VSSIO VDDIO diode_pd2nw_03v3 A=100P P=40U
* device instance $111 r0 *1 -52.16,12.5 diode_pd2nw_03v3
D$111 PAD VDDIO diode_pd2nw_03v3 A=20P P=18U
* device instance $112 r0 *1 36.7,0 ppolyf_u
R$112 \$84 PAD VSSIO 22.2727272727 ppolyf_u L=1.4U W=22U
.ENDS gf180_pad_core
