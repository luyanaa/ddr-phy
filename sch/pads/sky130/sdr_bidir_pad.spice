* GENERATED by generator/emit_pads.py -- DO NOT EDIT BY HAND
* backend: sky130   pdk: sky130A
* topology: specs/pads/topology.yaml v1 -- ONE shared schematic, only device names change
* STATUS: topology_template_only
* license: Apache-2.0 (SkyWater PDK Authors)
* SIZE UNITS: topology params are metres; sky130 subckts use .option scale=1u (micrometres), apply x1e6 when filling
* ESD NOTE: 2-terminal .model diodes; area unit and clamp orientation still need schematic review
*
* NOT SIMULATABLE. This is a TOPOLOGY TEMPLATE:
*   - every W / L / NF / R / area is an unresolved parameter
*     (see required_params.json). ngspice rejects them until filled.
*   - PAD_OE_CTRL is a generated transistor-level block (IO gates plus
*     an optional core-to-IO level shifter); its devices reuse the
*     pre-driver sizing placeholders and are not optimized.
*   - diode orientation, bulk ties and the series-R third terminal must
*     be confirmed at schematic review; they are NOT signed off here.
*   - L_R_SERIES is the on-chip resistor LENGTH. The target
*     resistance in ohm is a board-level SI input, not a pad param;
*     converting target R to L needs a per-PDK sheet resistance.
*
* Device-instantiation syntax is per backend (nf vs ng, m vs mr,
* r_length/r_width vs w/l, 2-terminal diode model vs 3-terminal ESD
* subckt). It lives in specs/pads/devices/<backend>.yaml; the block
* topology below stays shared.
*
* Expected includes (NOT bundled; integrator supplies models.spice):
*   libs.tech/ngspice/sky130.lib.spice (corner section tt/ss/ff)
*   none (device models only)
*
* Shared signal chain (docs/ARCHITECTURE.md section 5):
*   OUT/OE_N --[level shift if VDD != VDDIO]--> pre-driver --> tri-state
*   --> series R --> PAD --> ESD (to VDDIO / VSSIO + power clamp)
*   PAD --> CMOS/Schmitt RX --> [level shift back] --> IN
*   power-up Hi-Z until VDD and VDDIO are both present (PU_OK)

.subckt INV_IO A Y VDDIO VSSIO
X_INV_P Y A VDDIO VDDIO sky130_fd_pr__pfet_g5v0d10v5 w=W_P_PDRV l=L_PDRV nf=NF_DEVICE m=M_DEVICE
X_INV_N Y A VSSIO VSSIO sky130_fd_pr__nfet_g5v0d10v5 w=W_N_PDRV l=L_PDRV nf=NF_DEVICE m=M_DEVICE
.ends INV_IO
.subckt NAND2_IO A B Y VDDIO VSSIO
X_NAND_P1 Y A VDDIO VDDIO sky130_fd_pr__pfet_g5v0d10v5 w=W_P_PDRV l=L_PDRV nf=NF_DEVICE m=M_DEVICE
X_NAND_P2 Y B VDDIO VDDIO sky130_fd_pr__pfet_g5v0d10v5 w=W_P_PDRV l=L_PDRV nf=NF_DEVICE m=M_DEVICE
X_NAND_N1 Y A nand_mid VSSIO sky130_fd_pr__nfet_g5v0d10v5 w=W_N_PDRV l=L_PDRV nf=NF_DEVICE m=M_DEVICE
X_NAND_N2 nand_mid B VSSIO VSSIO sky130_fd_pr__nfet_g5v0d10v5 w=W_N_PDRV l=L_PDRV nf=NF_DEVICE m=M_DEVICE
.ends NAND2_IO
.subckt NOR2_IO A B Y VDDIO VSSIO
X_NOR_P1 Y A nor_mid VDDIO sky130_fd_pr__pfet_g5v0d10v5 w=W_P_PDRV l=L_PDRV nf=NF_DEVICE m=M_DEVICE
X_NOR_P2 nor_mid B VDDIO VDDIO sky130_fd_pr__pfet_g5v0d10v5 w=W_P_PDRV l=L_PDRV nf=NF_DEVICE m=M_DEVICE
X_NOR_N1 Y A VSSIO VSSIO sky130_fd_pr__nfet_g5v0d10v5 w=W_N_PDRV l=L_PDRV nf=NF_DEVICE m=M_DEVICE
X_NOR_N2 Y B VSSIO VSSIO sky130_fd_pr__nfet_g5v0d10v5 w=W_N_PDRV l=L_PDRV nf=NF_DEVICE m=M_DEVICE
.ends NOR2_IO
.subckt LS_C2I IN OUT OUTB VDD VSS VDDIO VSSIO
X_LS_INV_P INB IN VDD VDD sky130_fd_pr__pfet_01v8 w=W_P_PDRV l=L_PDRV nf=NF_DEVICE m=M_DEVICE
X_LS_INV_N INB IN VSS VSS sky130_fd_pr__nfet_01v8 w=W_N_PDRV l=L_PDRV nf=NF_DEVICE m=M_DEVICE
X_LS_N1 OUTB IN VSSIO VSSIO sky130_fd_pr__nfet_g5v0d10v5 w=W_N_PDRV*16 l=L_PDRV nf=NF_DEVICE m=M_DEVICE
X_LS_N2 OUT INB VSSIO VSSIO sky130_fd_pr__nfet_g5v0d10v5 w=W_N_PDRV*16 l=L_PDRV nf=NF_DEVICE m=M_DEVICE
X_LS_P1 OUTB OUT VDDIO VDDIO sky130_fd_pr__pfet_g5v0d10v5 w=W_P_PDRV l=L_PDRV nf=NF_DEVICE m=M_DEVICE
X_LS_P2 OUT OUTB VDDIO VDDIO sky130_fd_pr__pfet_g5v0d10v5 w=W_P_PDRV l=L_PDRV nf=NF_DEVICE m=M_DEVICE
.ends LS_C2I
.subckt PAD_OE_CTRL n_gp n_gn OUT OE_N PU_OK VDD VSS VDDIO VSSIO
X_LS OUT OUT_I OUTB_I VDD VSS VDDIO VSSIO LS_C2I
* OE_N and PU_OK are IO-domain control inputs in this macro
X_INV_OE OE_N OENB VDDIO VSSIO INV_IO
X_NAND PU_OK OENB EN_N VDDIO VSSIO NAND2_IO
X_NOR_GN EN_N OUT_I N_GN VDDIO VSSIO NOR2_IO
X_NOR_GP EN_N OUTB_I NGPB VDDIO VSSIO NOR2_IO
X_INV_NGP NGPB N_GP VDDIO VSSIO INV_IO
.ends PAD_OE_CTRL
.subckt sdr_bidir_pad OUT OE_N IN PAD PU_OK VDD VSS VDDIO VSSIO

* --- OE / power-up gating: real transistor-level block (see header) ---
X_OE_CTRL n_gp n_gn OUT OE_N PU_OK VDD VSS VDDIO VSSIO PAD_OE_CTRL

* --- pre-driver chain (even stage count preserves polarity) ---
X_PDRV_P_GP1 n_gp_s1 n_gp VDDIO VDDIO sky130_fd_pr__pfet_g5v0d10v5 w=W_P_PDRV l=L_PDRV nf=NF_DEVICE m=M_DEVICE
X_PDRV_N_GP1 n_gp_s1 n_gp VSSIO VSSIO sky130_fd_pr__nfet_g5v0d10v5 w=W_N_PDRV l=L_PDRV nf=NF_DEVICE m=M_DEVICE
X_PDRV_P_GP2 n_gp_drv n_gp_s1 VDDIO VDDIO sky130_fd_pr__pfet_g5v0d10v5 w=W_P_PDRV l=L_PDRV nf=NF_DEVICE m=M_DEVICE
X_PDRV_N_GP2 n_gp_drv n_gp_s1 VSSIO VSSIO sky130_fd_pr__nfet_g5v0d10v5 w=W_N_PDRV l=L_PDRV nf=NF_DEVICE m=M_DEVICE
X_PDRV_P_GN1 n_gn_s1 n_gn VDDIO VDDIO sky130_fd_pr__pfet_g5v0d10v5 w=W_P_PDRV l=L_PDRV nf=NF_DEVICE m=M_DEVICE
X_PDRV_N_GN1 n_gn_s1 n_gn VSSIO VSSIO sky130_fd_pr__nfet_g5v0d10v5 w=W_N_PDRV l=L_PDRV nf=NF_DEVICE m=M_DEVICE
X_PDRV_P_GN2 n_gn_drv n_gn_s1 VDDIO VDDIO sky130_fd_pr__pfet_g5v0d10v5 w=W_P_PDRV l=L_PDRV nf=NF_DEVICE m=M_DEVICE
X_PDRV_N_GN2 n_gn_drv n_gn_s1 VSSIO VSSIO sky130_fd_pr__nfet_g5v0d10v5 w=W_N_PDRV l=L_PDRV nf=NF_DEVICE m=M_DEVICE

* --- tri-state output (PMOS to VDDIO, NMOS to VSSIO) ---
X_OUT_P n_pre n_gp_drv VDDIO VDDIO sky130_fd_pr__pfet_g5v0d10v5 w=W_P_OUT l=L_P_OUT nf=NF_P_OUT m=M_DEVICE
X_OUT_N n_pre n_gn_drv VSSIO VSSIO sky130_fd_pr__nfet_g5v0d10v5 w=W_N_OUT l=L_N_OUT nf=NF_N_OUT m=M_DEVICE

* --- on-chip series damping resistor (may instead live on the board) ---
X_RSER n_pre PAD VSSIO sky130_fd_pr__res_high_po w=W_R_SERIES l=L_R_SERIES

* --- ESD: primary diodes + VDDIO-to-VSSIO clamp ---
D_ESD_UP PAD VDDIO sky130_fd_pr__diode_pd2nw_11v0 area=ESD_AREA_UP
D_ESD_DN VSSIO PAD sky130_fd_pr__diode_pw2nd_11v0 area=ESD_AREA_DN
D_CLAMP VSSIO VDDIO sky130_fd_pr__diode_pd2nw_11v0 area=ESD_CLAMP_W

* --- SDR receiver: thick-oxide CMOS inverter (Schmitt optional) ---
X_RX_N IN PAD VSSIO VSSIO sky130_fd_pr__nfet_g5v0d10v5 w=W_RX_N l=L_PDRV nf=NF_DEVICE m=M_DEVICE
X_RX_P IN PAD VDDIO VDDIO sky130_fd_pr__pfet_g5v0d10v5 w=W_RX_P l=L_PDRV nf=NF_DEVICE m=M_DEVICE
* RX_HYST unresolved; do NOT assume the input threshold equals VDDIO/2.

* --- IO -> core level shifter for IN: topology TBD (not a drawn netlist) ---

* --- guard ring surrounds output stage and ESD (layout only) ---
* GUARD_RING_WIDTH / GUARD_RING_SPACING unresolved; not drawn here.
.ends sdr_bidir_pad
