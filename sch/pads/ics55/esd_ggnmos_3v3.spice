* GENERATED by generator/emit_ics55_esd.py -- DO NOT EDIT BY HAND
* backend: ics55
* STATUS: STUDY_ONLY - NOT A QUALIFIED ESD CELL
* license: foundry SPICE evaluation-only; not Apache-2.0
*
* NOT SIMULATABLE. Every W/L/NF/R is null. This is a topology prototype
* for an ics55 3.3 V ESD clamp. BSIM4 does not model snapback, so no SPICE
* run can establish trigger/holding/It2. TLP/HBM/latch-up data is required.
*
* PAD -> VSSIO: GGNMOS, gate resistor to VSSIO
* PAD -> VDDIO: GGPMOS, gate resistor to VDDIO
* VDDIO -> VSSIO: GGNMOS power clamp, gate resistor to VSSIO
*
* Do NOT bind this into the ics55 SDR pad until the TLP/HBM evidence exists.

.subckt ics55_esd_3v3 PAD VDDIO VSSIO
* --- PAD-to-VSSIO GGNMOS ---
X_GGN PAD n_g_n VSSIO VSSIO nmod3p3_lp w=W_N_PAD l=L_N_PAD nf=NF_N_PAD mr=1
R_GN n_g_n VSSIO R_GATE_N
* --- PAD-to-VDDIO GGPMOS ---
X_GGP PAD n_g_p VDDIO VDDIO pmod3p3_lp w=W_P_PAD l=L_P_PAD nf=NF_P_PAD mr=1
R_GP n_g_p VDDIO R_GATE_P
* --- VDDIO-to-VSSIO GGNMOS power clamp ---
X_GGC VDDIO n_g_c VSSIO VSSIO nmod3p3_lp w=W_N_RAIL l=L_N_RAIL nf=NF_N_RAIL mr=1
R_GC n_g_c VSSIO R_GATE_RAIL
.ends ics55_esd_3v3
