* LAYOUT SLICE schematic for LVS: output stage + series R + ESD + receiver.
* Gate pins are external in this slice; OE logic/pre-driver are not laid out yet.
.SUBCKT gf180_pad_core GP GN PAD VDDIO VSSIO
MP NPRE GP VDDIO VDDIO pfet_03v3 W=200u L=0.28u
MN NPRE GN VSSIO VSSIO nfet_03v3 W=80u L=0.28u
R1 NPRE PAD VSSIO ppolyf_u L=1.4u W=22u
DUP PAD VDDIO diode_pd2nw_03v3 A=20p P=18u
DDN VSSIO PAD diode_nd2ps_03v3 A=20p P=18u
DCLAMP VSSIO VDDIO diode_pd2nw_03v3 A=100p P=40u
MRN IN PAD VSSIO VSSIO nfet_03v3 W=2u L=0.28u
MRP IN PAD VDDIO VDDIO pfet_03v3 W=4u L=0.28u
.ENDS
