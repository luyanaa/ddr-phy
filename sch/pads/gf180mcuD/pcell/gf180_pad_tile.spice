* PAD MACRO schematic for LVS: output stage + series R + ESD + receiver
* + OE logic + pre-driver (IO domain, W_N=1u W_P=2u L=0.28u).
.SUBCKT gf180_pad_core OUT OE_N PU_OK PAD IN VDDIO VSSIO
MP NPRE GP VDDIO VDDIO pfet_03v3 W=200u L=0.28u
MN NPRE GN VSSIO VSSIO nfet_03v3 W=80u L=0.28u
R1 NPRE PAD VSSIO ppolyf_u L=1.4u W=22u
DUP PAD VDDIO diode_pd2nw_03v3 A=64p P=32u
DDN VSSIO PAD diode_nd2ps_03v3 A=64p P=32u
DDN2 VSSIO PAD diode_nd2ps_03v3 A=64p P=32u
DCLAMP VSSIO VDDIO diode_pd2nw_03v3 A=100p P=40u
MRN IN PAD VSSIO VSSIO nfet_03v3 W=2u L=0.28u
MRP IN PAD VDDIO VDDIO pfet_03v3 W=4u L=0.28u
MPOB OUTB_I OUT VDDIO VDDIO pfet_03v3 W=2u L=0.28u
MNOB OUTB_I OUT VSSIO VSSIO nfet_03v3 W=1u L=0.28u
MCLAMP PAD VSSIO VSSIO VSSIO nfet_03v3 W=160u L=0.28u
MPOE OENB OE_N VDDIO VDDIO pfet_03v3 W=2u L=0.28u
MNOE OENB OE_N VSSIO VSSIO nfet_03v3 W=1u L=0.28u
MPNGP N_GP NGPB VDDIO VDDIO pfet_03v3 W=2u L=0.28u
MNGNP N_GP NGPB VSSIO VSSIO nfet_03v3 W=1u L=0.28u
MPNA1 EN_N PU_OK VDDIO VDDIO pfet_03v3 W=2u L=0.28u
MPNA2 EN_N OENB VDDIO VDDIO pfet_03v3 W=2u L=0.28u
MNNA1 EN_N PU_OK MID_NA VSSIO nfet_03v3 W=1u L=0.28u
MNNA2 MID_NA OENB VSSIO VSSIO nfet_03v3 W=1u L=0.28u
MPG1 MID_GP EN_N VDDIO VDDIO pfet_03v3 W=2u L=0.28u
MPG2 NGPB OUTB_I MID_GP VDDIO pfet_03v3 W=2u L=0.28u
MNG1 NGPB EN_N VSSIO VSSIO nfet_03v3 W=1u L=0.28u
MNG2 NGPB OUTB_I VSSIO VSSIO nfet_03v3 W=1u L=0.28u
MPH1 MID_GN EN_N VDDIO VDDIO pfet_03v3 W=2u L=0.28u
MPH2 N_GN OUT MID_GN VDDIO pfet_03v3 W=2u L=0.28u
MNH1 N_GN EN_N VSSIO VSSIO nfet_03v3 W=1u L=0.28u
MNH2 N_GN OUT VSSIO VSSIO nfet_03v3 W=1u L=0.28u
MPGP1 N_GP_S1 N_GP VDDIO VDDIO pfet_03v3 W=2u L=0.28u
MNGP1 N_GP_S1 N_GP VSSIO VSSIO nfet_03v3 W=1u L=0.28u
MPGP2 GP N_GP_S1 VDDIO VDDIO pfet_03v3 W=2u L=0.28u
MNGP2 GP N_GP_S1 VSSIO VSSIO nfet_03v3 W=1u L=0.28u
MPGN1 N_GN_S1 N_GN VDDIO VDDIO pfet_03v3 W=2u L=0.28u
MNGN1 N_GN_S1 N_GN VSSIO VSSIO nfet_03v3 W=1u L=0.28u
MPGN2 GN N_GN_S1 VDDIO VDDIO pfet_03v3 W=2u L=0.28u
MNGN2 GN N_GN_S1 VSSIO VSSIO nfet_03v3 W=1u L=0.28u
.ENDS

.SUBCKT gf180_pad_tile OUT OE_N PU_OK PAD IN VDDIO VSSIO
Xpad OUT OE_N PU_OK PAD IN VDDIO VSSIO gf180_pad_core
.ENDS
