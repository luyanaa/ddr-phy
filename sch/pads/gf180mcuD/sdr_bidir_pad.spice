* GENERATED by generator/emit_pads.py -- DO NOT EDIT BY HAND
* backend: gf180mcuD   pdk: gf180mcuD
* topology: specs/pads/topology.yaml v1 -- ONE shared schematic, only device names change
* STATUS: topology_template_only
* license: Apache-2.0 (GlobalFoundries PDK Authors, design.ngspice header)
* SIZE UNITS: topology params are metres; nfet_03v3/pfet_03v3 take w/l in metres
* ESD NOTE: 2-terminal .model diodes; area unit and orientation still need schematic review
*
* NOT SIMULATABLE. This is a TOPOLOGY TEMPLATE:
*   - every W / L / NF / R / area is an unresolved parameter
*     (see required_params.json). ngspice rejects them until filled.
*   - PAD_OE_CTRL is a named placeholder subcircuit, not a supplied
*     block. The generator will expand it once the backend cell library
*     and PDRV_STAGES are bound.
*   - diode orientation, bulk ties and the series-R third terminal must
*     be confirmed at schematic review; they are NOT signed off here.
*   - L_R_SERIES is the on-chip resistor LENGTH. The target
*     resistance in ohm is a board-level SI input, not a pad param;
*     converting target R to L needs a per-PDK sheet resistance.
*
* Device-instantiation syntax is per backend (nf vs ng, m vs mr,
* r_length/r_width vs w/l, 2-terminal diode model vs 3-terminal ESD
* subckt). It lives in specs/pads/devices/<backend>.yaml; the block
* topology below stays shared.
*
* Expected includes (NOT bundled; integrator supplies models.spice):
*   libs.tech/ngspice/sm141064.ngspice
*   libs.tech/ngspice/design.ngspice
*
* Shared signal chain (docs/ARCHITECTURE.md section 5):
*   OUT/OE_N --[level shift if VDD != VDDIO]--> pre-driver --> tri-state
*   --> series R --> PAD --> ESD (to VDDIO / VSSIO + power clamp)
*   PAD --> CMOS/Schmitt RX --> [level shift back] --> IN
*   power-up Hi-Z until VDD and VDDIO are both present (PU_OK)

.subckt sdr_bidir_pad OUT OE_N IN PAD PU_OK VDD VSS VDDIO VSSIO

* --- core_v == vddio_v: NO level shifter (Nominal core and IO voltages are equal; ARCHITECTURE.md section 5.1 says no level shift. Pre-driver still required.) ---
* OUT / OE_N are already at IO-domain levels; pre-driver still required.

* --- OE / power-up gating: named placeholder, NOT supplied ---
X_OE_CTRL n_gp n_gn OUT OE_N PU_OK VDDIO VSSIO PAD_OE_CTRL

* --- pre-driver chain (even stage count preserves polarity) ---
X_PDRV_P_GP1 n_gp_s1 n_gp VDDIO VDDIO pfet_03v3 w=W_P_PDRV l=L_PDRV nf=NF_DEVICE m=M_DEVICE
X_PDRV_N_GP1 n_gp_s1 n_gp VSSIO VSSIO nfet_03v3 w=W_N_PDRV l=L_PDRV nf=NF_DEVICE m=M_DEVICE
X_PDRV_P_GP2 n_gp_drv n_gp_s1 VDDIO VDDIO pfet_03v3 w=W_P_PDRV l=L_PDRV nf=NF_DEVICE m=M_DEVICE
X_PDRV_N_GP2 n_gp_drv n_gp_s1 VSSIO VSSIO nfet_03v3 w=W_N_PDRV l=L_PDRV nf=NF_DEVICE m=M_DEVICE
X_PDRV_P_GN1 n_gn_s1 n_gn VDDIO VDDIO pfet_03v3 w=W_P_PDRV l=L_PDRV nf=NF_DEVICE m=M_DEVICE
X_PDRV_N_GN1 n_gn_s1 n_gn VSSIO VSSIO nfet_03v3 w=W_N_PDRV l=L_PDRV nf=NF_DEVICE m=M_DEVICE
X_PDRV_P_GN2 n_gn_drv n_gn_s1 VDDIO VDDIO pfet_03v3 w=W_P_PDRV l=L_PDRV nf=NF_DEVICE m=M_DEVICE
X_PDRV_N_GN2 n_gn_drv n_gn_s1 VSSIO VSSIO nfet_03v3 w=W_N_PDRV l=L_PDRV nf=NF_DEVICE m=M_DEVICE

* --- tri-state output (PMOS to VDDIO, NMOS to VSSIO) ---
X_OUT_P n_pre n_gp_drv VDDIO VDDIO pfet_03v3 w=W_P_OUT l=L_P_OUT nf=NF_P_OUT m=M_DEVICE
X_OUT_N n_pre n_gn_drv VSSIO VSSIO nfet_03v3 w=W_N_OUT l=L_N_OUT nf=NF_N_OUT m=M_DEVICE

* --- on-chip series damping resistor (may instead live on the board) ---
X_RSER n_pre PAD VSSIO ppolyf_u r_length=L_R_SERIES r_width=W_R_SERIES

* --- ESD: primary diodes + VDDIO-to-VSSIO clamp ---
D_ESD_UP PAD VDDIO diode_pd2nw_03v3 area=ESD_AREA_UP
D_ESD_DN VSSIO PAD diode_nd2ps_03v3 area=ESD_AREA_DN
D_CLAMP VSSIO VDDIO diode_pd2nw_03v3 area=ESD_CLAMP_W

* --- SDR receiver: thick-oxide CMOS inverter (Schmitt optional) ---
X_RX_N IN PAD VSSIO VSSIO nfet_03v3 w=W_RX_N l=L_PDRV nf=NF_DEVICE m=M_DEVICE
X_RX_P IN PAD VDDIO VDDIO pfet_03v3 w=W_RX_P l=L_PDRV nf=NF_DEVICE m=M_DEVICE
* RX_HYST unresolved; do NOT assume the input threshold equals VDDIO/2.

* --- guard ring surrounds output stage and ESD (layout only) ---
* GUARD_RING_WIDTH / GUARD_RING_SPACING unresolved; not drawn here.
.ends sdr_bidir_pad
