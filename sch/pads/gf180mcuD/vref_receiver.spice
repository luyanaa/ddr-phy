* GENERATED by generator/emit_pads.py -- DO NOT EDIT BY HAND
* backend: gf180mcuD   pdk: gf180mcuD
* topology: specs/pads/topology.yaml v1 (DDR1 VREF receiver, shared across PDKs)
* STATUS: topology_template_only
* SIZE UNITS: topology params are metres; nfet_03v3/pfet_03v3 take w/l in metres
* ESD NOTE: 2-terminal .model diodes; area unit and orientation still need schematic review
* DDR1 decision for this backend: DEFERRED_LONG_TERM
* Long-term plan, not a current deliverable. ARCHITECTURE.md section 1 already says gf180 DDR1 is not done this period; section 6 now records it as DEFERRED rather than a hard exclusion. Still blocked: 2.5 V SSTL_2 / VREF IO, no 2.5 V device model, unresolved ck90, and an uncharacterized VREF receiver.
*
* NOT SIMULATABLE. W / I / common-mode / offset / hysteresis are all
* unresolved parameters (required_params.json). ngspice rejects them
* until filled. The ideal tail current source is a placeholder for a
* characterized current mirror, not a designed bias circuit.
*
* Expected includes (NOT bundled): libs.tech/ngspice/sm141064.ngspice ; libs.tech/ngspice/design.ngspice
*
* Device-instantiation syntax is per backend; the differential-pair
* topology is shared. See specs/pads/devices/<backend>.yaml.
*
* DDR1 read capture topology:
*   PAD and VREF are both VDDIO-domain inputs -> IO devices only.
*   Differential pair + PMOS mirror load -> single-ended -> RX buffer.
*   No DAC, no ADC, no digital output driver on the VREF pad.

.subckt vref_receiver PAD VREF IN PU_OK VDD VSS VDDIO VSSIO
* --- differential pair ---
X_VP n_outp PAD n_tail VSSIO nfet_03v3 w=W_VREF_N l=L_PDRV nf=NF_DEVICE m=M_DEVICE
X_VN n_outn VREF n_tail VSSIO nfet_03v3 w=W_VREF_N l=L_PDRV nf=NF_DEVICE m=M_DEVICE
* --- tail current: ideal placeholder ---
I_TAIL n_tail VSSIO DC I_TAIL
* W_TAIL belongs to the real current mirror, TBD.
* --- PMOS current-mirror load ---
X_LP n_outp n_outp VDDIO VDDIO pfet_03v3 w=W_LOAD l=L_PDRV nf=NF_DEVICE m=M_DEVICE
X_LN n_outn n_outp VDDIO VDDIO pfet_03v3 w=W_LOAD l=L_PDRV nf=NF_DEVICE m=M_DEVICE
* --- single-ended output buffer ---
X_RX_N IN n_outn VSSIO VSSIO nfet_03v3 w=W_RX_N l=L_PDRV nf=NF_DEVICE m=M_DEVICE
X_RX_P IN n_outn VDDIO VDDIO pfet_03v3 w=W_RX_P l=L_PDRV nf=NF_DEVICE m=M_DEVICE
* Unresolved: VREF_CM_MIN / VREF_CM_MAX / VREF_OFFSET / VREF_HYST.
* Common-mode range, offset and hysteresis are NOT reported here.
.ends vref_receiver

* VREF pad: ESD diodes + metal ONLY. No output driver, no DAC/ADC.
.subckt vref_pad VREF VDDIO VSSIO
D_VREF_UP VREF VDDIO diode_pd2nw_03v3 area=ESD_AREA_UP
D_VREF_DN VSSIO VREF diode_nd2ps_03v3 area=ESD_AREA_DN
.ends vref_pad
