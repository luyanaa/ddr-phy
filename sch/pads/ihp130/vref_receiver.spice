* GENERATED by generator/emit_pads.py -- DO NOT EDIT BY HAND
* backend: ihp130   pdk: ihp-sg13g2
* topology: specs/pads/topology.yaml v1 (DDR1 VREF receiver, shared across PDKs)
* STATUS: topology_template_only
* SIZE UNITS: topology params are metres; HV/LV subckts take w/l in metres (u suffix accepted)
* ESD NOTE: fixed-geometry 2 kV ESD subckts; ESD_AREA_* params are NOT applied
* DDR1 decision for this backend: TBD
* 2.5 V operating point uncharacterized; no 2.5 V device; VREF receiver is topology only
*
* NOT SIMULATABLE. W / I / common-mode / offset / hysteresis are all
* unresolved parameters (required_params.json). ngspice rejects them
* until filled. The ideal tail current source is a placeholder for a
* characterized current mirror, not a designed bias circuit.
*
* Expected includes (NOT bundled): libs.tech/ngspice/models/cornerMOShv.lib; cornerMOSlv.lib; cornerRES.lib; sg13g2_esd.lib ; none (device models only)
*
* Device-instantiation syntax is per backend; the differential-pair
* topology is shared. See specs/pads/devices/<backend>.yaml.
*
* DDR1 read capture topology:
*   PAD and VREF are both VDDIO-domain inputs -> IO devices only.
*   Differential pair + PMOS mirror load -> single-ended -> RX buffer.
*   No DAC, no ADC, no digital output driver on the VREF pad.

.subckt vref_receiver PAD VREF IN PU_OK VDD VSS VDDIO VSSIO
* --- differential pair ---
X_VP n_outp PAD n_tail VSSIO sg13_hv_nmos w=W_VREF_N l=L_PDRV ng=NF_DEVICE m=M_DEVICE
X_VN n_outn VREF n_tail VSSIO sg13_hv_nmos w=W_VREF_N l=L_PDRV ng=NF_DEVICE m=M_DEVICE
* --- tail current: ideal placeholder ---
I_TAIL n_tail VSSIO DC I_TAIL
* W_TAIL belongs to the real current mirror, TBD.
* --- PMOS current-mirror load ---
X_LP n_outp n_outp VDDIO VDDIO sg13_hv_pmos w=W_LOAD l=L_PDRV ng=NF_DEVICE m=M_DEVICE
X_LN n_outn n_outp VDDIO VDDIO sg13_hv_pmos w=W_LOAD l=L_PDRV ng=NF_DEVICE m=M_DEVICE
* --- single-ended output buffer ---
X_RX_N IN n_outn VSSIO VSSIO sg13_hv_nmos w=W_RX_N l=L_PDRV ng=NF_DEVICE m=M_DEVICE
X_RX_P IN n_outn VDDIO VDDIO sg13_hv_pmos w=W_RX_P l=L_PDRV ng=NF_DEVICE m=M_DEVICE
* Unresolved: VREF_CM_MIN / VREF_CM_MAX / VREF_OFFSET / VREF_HYST.
* Common-mode range, offset and hysteresis are NOT reported here.
.ends vref_receiver

* VREF pad: ESD diodes + metal ONLY. No output driver, no DAC/ADC.
.subckt vref_pad VREF VDDIO VSSIO
X_VREF_UP VDDIO VREF VSSIO diodevdd_2kv
X_VREF_DN VDDIO VREF VSSIO diodevss_2kv
.ends vref_pad
