* GENERATED by generator/emit_pads.py -- DO NOT EDIT BY HAND
* backend: ihp130   pdk: ihp-sg13g2
* topology: specs/pads/topology.yaml v1 -- ONE shared schematic, only device names change
* STATUS: topology_template_only
* license: Apache-2.0 (IHP PDK Authors)
* SIZE UNITS: topology params are metres; HV/LV subckts take w/l in metres (u suffix accepted)
* ESD NOTE: fixed-geometry 2 kV ESD subckts; ESD_AREA_* params are NOT applied
*
* NOT SIMULATABLE. This is a TOPOLOGY TEMPLATE:
*   - every W / L / NF / R / area is an unresolved parameter
*     (see required_params.json). ngspice rejects them until filled.
*   - PAD_OE_CTRL is a named placeholder subcircuit, not a supplied
*     block. The generator will expand it once the backend cell library
*     and PDRV_STAGES are bound.
*   - diode orientation, bulk ties and the series-R third terminal must
*     be confirmed at schematic review; they are NOT signed off here.
*   - L_R_SERIES is the on-chip resistor LENGTH. The target
*     resistance in ohm is a board-level SI input, not a pad param;
*     converting target R to L needs a per-PDK sheet resistance.
*
* Device-instantiation syntax is per backend (nf vs ng, m vs mr,
* r_length/r_width vs w/l, 2-terminal diode model vs 3-terminal ESD
* subckt). It lives in specs/pads/devices/<backend>.yaml; the block
* topology below stays shared.
*
* Expected includes (NOT bundled; integrator supplies models.spice):
*   libs.tech/ngspice/models/cornerMOShv.lib; cornerMOSlv.lib; cornerRES.lib; sg13g2_esd.lib
*   none (device models only)
*
* Shared signal chain (docs/ARCHITECTURE.md section 5):
*   OUT/OE_N --[level shift if VDD != VDDIO]--> pre-driver --> tri-state
*   --> series R --> PAD --> ESD (to VDDIO / VSSIO + power clamp)
*   PAD --> CMOS/Schmitt RX --> [level shift back] --> IN
*   power-up Hi-Z until VDD and VDDIO are both present (PU_OK)

.subckt sdr_bidir_pad OUT OE_N IN PAD PU_OK VDD VSS VDDIO VSSIO

* --- core -> IO level shifter (VDD != VDDIO): 4 devices, sizes TBD ---
X_LS_N n_lsn OUT VSS VSS sg13_lv_nmos w=W_N_PDRV l=L_PDRV ng=NF_DEVICE m=M_DEVICE
X_LS_P n_lsp OUT VDD VDD sg13_lv_pmos w=W_P_PDRV l=L_PDRV ng=NF_DEVICE m=M_DEVICE
X_LS_N2 n_lsn n_lsp VSSIO VSSIO sg13_hv_nmos w=W_N_PDRV l=L_PDRV ng=NF_DEVICE m=M_DEVICE
X_LS_P2 n_lsp n_lsn VDDIO VDDIO sg13_hv_pmos w=W_P_PDRV l=L_PDRV ng=NF_DEVICE m=M_DEVICE

* --- OE / power-up gating: named placeholder, NOT supplied ---
X_OE_CTRL n_gp n_gn OUT OE_N PU_OK VDDIO VSSIO PAD_OE_CTRL

* --- pre-driver chain (even stage count preserves polarity) ---
X_PDRV_P_GP1 n_gp_s1 n_gp VDDIO VDDIO sg13_hv_pmos w=W_P_PDRV l=L_PDRV ng=NF_DEVICE m=M_DEVICE
X_PDRV_N_GP1 n_gp_s1 n_gp VSSIO VSSIO sg13_hv_nmos w=W_N_PDRV l=L_PDRV ng=NF_DEVICE m=M_DEVICE
X_PDRV_P_GP2 n_gp_drv n_gp_s1 VDDIO VDDIO sg13_hv_pmos w=W_P_PDRV l=L_PDRV ng=NF_DEVICE m=M_DEVICE
X_PDRV_N_GP2 n_gp_drv n_gp_s1 VSSIO VSSIO sg13_hv_nmos w=W_N_PDRV l=L_PDRV ng=NF_DEVICE m=M_DEVICE
X_PDRV_P_GN1 n_gn_s1 n_gn VDDIO VDDIO sg13_hv_pmos w=W_P_PDRV l=L_PDRV ng=NF_DEVICE m=M_DEVICE
X_PDRV_N_GN1 n_gn_s1 n_gn VSSIO VSSIO sg13_hv_nmos w=W_N_PDRV l=L_PDRV ng=NF_DEVICE m=M_DEVICE
X_PDRV_P_GN2 n_gn_drv n_gn_s1 VDDIO VDDIO sg13_hv_pmos w=W_P_PDRV l=L_PDRV ng=NF_DEVICE m=M_DEVICE
X_PDRV_N_GN2 n_gn_drv n_gn_s1 VSSIO VSSIO sg13_hv_nmos w=W_N_PDRV l=L_PDRV ng=NF_DEVICE m=M_DEVICE

* --- tri-state output (PMOS to VDDIO, NMOS to VSSIO) ---
X_OUT_P n_pre n_gp_drv VDDIO VDDIO sg13_hv_pmos w=W_P_OUT l=L_P_OUT ng=NF_P_OUT m=M_DEVICE
X_OUT_N n_pre n_gn_drv VSSIO VSSIO sg13_hv_nmos w=W_N_OUT l=L_N_OUT ng=NF_N_OUT m=M_DEVICE

* --- on-chip series damping resistor (may instead live on the board) ---
X_RSER n_pre PAD VSSIO rppd w=W_R_SERIES l=L_R_SERIES

* --- ESD: primary diodes + VDDIO-to-VSSIO clamp ---
X_ESD_UP VDDIO PAD VSSIO diodevdd_2kv
X_ESD_DN VDDIO PAD VSSIO diodevss_2kv
X_CLAMP VDDIO VSSIO VSSIO diodevdd_2kv

* --- SDR receiver: thick-oxide CMOS inverter (Schmitt optional) ---
X_RX_N IN PAD VSSIO VSSIO sg13_hv_nmos w=W_RX_N l=L_PDRV ng=NF_DEVICE m=M_DEVICE
X_RX_P IN PAD VDDIO VDDIO sg13_hv_pmos w=W_RX_P l=L_PDRV ng=NF_DEVICE m=M_DEVICE
* RX_HYST unresolved; do NOT assume the input threshold equals VDDIO/2.

* --- IO -> core level shifter for IN: topology TBD (not a drawn netlist) ---

* --- guard ring surrounds output stage and ESD (layout only) ---
* GUARD_RING_WIDTH / GUARD_RING_SPACING unresolved; not drawn here.
.ends sdr_bidir_pad
